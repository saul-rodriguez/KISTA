ADE simulation setup
Run mode: Single Run, Sweeps and Corners
Tests:
  KISTA_TEST_AMS:test_ams_dffsrx1:1 (off): KISTA_TEST_AMS/test_ams_dffsrx1/config, simulator ams
  KISTA_TEST_AMS:test_ams_dffsrx1:1:1: KISTA_TEST_AMS/test_ams_dffsrx1/config, simulator ams
