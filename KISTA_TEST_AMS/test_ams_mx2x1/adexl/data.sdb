ADE simulation setup
Run mode: Single Run, Sweeps and Corners
Tests:
  KISTA_TEST_AMS:test_ams_mx2x1:1: KISTA_TEST_AMS/test_ams_mx2x1/config, simulator ams
