ADE simulation setup
Run mode: Single Run, Sweeps and Corners
Tests:
  KISTA_TEST_AMS:test_ams_aoi:1: KISTA_TEST_AMS/test_ams_aoi/config, simulator ams
