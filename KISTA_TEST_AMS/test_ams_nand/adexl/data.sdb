ADE simulation setup
Run mode: Single Run, Sweeps and Corners
Tests:
  KISTA_TEST_AMS:test_ams_nand:1: KISTA_TEST_AMS/test_ams_nand/config, simulator ams
