ADE simulation setup
Run mode: Single Run, Sweeps and Corners
Tests:
  KISTA_TEST_AMS:test_soi_inv:1 (off): KISTA_TEST_AMS/test_soi_inv/config, simulator spectre
  KISTA_TEST_AMS:test_soi_inv:2: KISTA_TEST_AMS/test_soi_inv/config, simulator ams
