ADE simulation setup
Run mode: Single Run, Sweeps and Corners
Tests:
  KISTA_TEST_AMS:test_ams_nand3:1: KISTA_TEST_AMS/test_ams_nand3/config, simulator ams
