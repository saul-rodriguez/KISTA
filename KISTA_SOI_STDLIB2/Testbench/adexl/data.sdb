ADE simulation setup
Run mode: Single Run, Sweeps and Corners
Tests:
  KISTA_SOI_STDLIB2:Testbench:1: KISTA_SOI_STDLIB2/Testbench/config, simulator ams
    Outputs: "/YX1"; "/Q"; /B; "/S0"; /S0; /C; /D; /S1; "/Y"; /D_FF; /CK; "/SN"; "/RN"; /SN; /RN; /Y
