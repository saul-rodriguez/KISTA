// Generated for: spectre
// Generated on: Dec 21 14:49:39 2021
// Design library name: KISTA_SOI_STDLIB
// Design cell name: timing
// Design view name: schematic
simulator lang=spectre
global 0 VSS! VDD!

// Library name: KISTA_SOI_STDLIB
// Cell name: INVX1
// View name: analog_extracted
subckt INVX1_analog_extracted Y A
    Rc4 (Y\#1 Y) resistor r=2.5
    Rc3 (Y Y\#3) resistor r=5.23
    Rc5 (VDD! VDD!\#1) resistor r=2.8463
    Rc6 (VSS! VSS!\#1) resistor r=5.3718
    Rd2 (A\#3 A) resistor r=450.9252
    Rs (1 VSS!) resistor r=50
    Rd1 (A\#2 A\#3) resistor r=459.2584
    Rd3 (A\#3 A\#4) resistor r=459.2584
    C7 (VDD! VSS!) capacitor c=4.80699e-15
    C3 (VSS! A) capacitor c=1.99163e-15
    C9 (1 VSS!) capacitor c=18.9849f
    C1 (Y\#1 VSS!) capacitor c=1.86121e-15
    C2 (Y\#3 VSS!) capacitor c=1.06371e-15
    C4 (A\#2 VSS!) capacitor c=1.20051e-15
    C6 (A\#3 VSS!) capacitor c=1.54228e-15
    C8 (VDD!\#1 VSS!) capacitor c=1.95119e-15
    C10 (X1_5 VSS!) capacitor c=1.60447e-15
    C5 (A\#4 VSS!) capacitor c=1.0839e-15
    MX1_M0_unmatched (Y\#1 A\#2 VDD!\#1 VDD!\#1) pch w=4e-06 l=1e-06 as=0 \
        ad=1e-11 ps=0 pd=1.3e-05 sa=2e-06 sb=2e-06
    MX0_M0_unmatched (Y\#3 A\#4 VSS!\#1 VSS!\#1) nch w=2e-06 l=1e-06 as=0 \
        ad=5e-12 ps=0 pd=9e-06 sa=2e-06 sb=2e-06
ends INVX1_analog_extracted
// End of subcircuit definition.

// Library name: KISTA_SOI_STDLIB
// Cell name: NOR2X1
// View name: analog_extracted
subckt NOR2X1_analog_extracted A Y B
    C46 (B\#1 3) capacitor c=702.269a
    C49 (B\#1 net9) capacitor c=247.812a
    C5 (B\#1 VDD!) capacitor c=22.1274a
    C6 (3 VDD!) capacitor c=6.82798e-15
    C8 (net9 VDD!) capacitor c=26.7824a
    C1 (VSS! VDD!) capacitor c=6.28194e-18
    C20 (B\#1 VSS!) capacitor c=3.08722e-18
    C23 (3 VSS!) capacitor c=6.66291e-15
    C4 (Y VDD!) capacitor c=26.333a
    C16 (Y VSS!) capacitor c=1.28683e-18
    C37 (B\#1 Y) capacitor c=307.556a
    C42 (net9 Y) capacitor c=152.931a
    C41 (Y\#3 3) capacitor c=5.38241e-15
    C7 (VDD!\#1 3) capacitor c=322.18a
    C2 (VDD!\#1 A) capacitor c=22.1511a
    C13 (A VSS!) capacitor c=10.2837a
    C31 (3 A) capacitor c=3.38372e-15
    C3 (VDD!\#1 A\#4) capacitor c=303.441a
    C27 (A\#4 Y) capacitor c=3.48881e-18
    C44 (X5_5 Y) capacitor c=636.131a
    C11 (X5_5 VDD!) capacitor c=45.0485a
    C9 (net9\#2 VDD!) capacitor c=30.3639a
    C10 (VDD!\#1 net9\#2) capacitor c=146.624a
    C26 (net9\#2 VSS!) capacitor c=5.29192e-19
    C32 (A\#4 3) capacitor c=643.213a
    C35 (net9\#2 A\#4) capacitor c=248.735a
    C50 (B\#1 X5_5) capacitor c=526.868a
    C52 (X5_5 net9) capacitor c=186.459a
    C22 (B\#2 VSS!) capacitor c=5.01933e-18
    C40 (B\#2 Y\#3) capacitor c=727.441a
    C48 (B\#2 3) capacitor c=2.55904e-15
    C51 (net9\#2 3) capacitor c=103.803a
    C12 (VDD!\#1 X4_5) capacitor c=636.131a
    C36 (A\#4 X4_5) capacitor c=503.459a
    C53 (net9\#2 X4_5) capacitor c=209.118a
    C43 (Y\#4 net9\#2) capacitor c=4.81054e-18
    C15 (A\#5 VSS!) capacitor c=1.39239e-19
    C28 (Y\#4 A) capacitor c=374.885a
    C30 (A\#5 Y\#4) capacitor c=4.70031e-18
    C34 (A\#5 3) capacitor c=40.1876a
    C29 (Y\#4 A\#6) capacitor c=396.962a
    C33 (A\#6 3) capacitor c=1.35929e-15
    C14 (VSS!\#2 A\#6) capacitor c=130.44a
    C17 (VSS!\#2 Y\#4) capacitor c=102.564a
    C25 (VSS!\#2 3) capacitor c=2.10042e-15
    C18 (Y\#3 VSS!\#1) capacitor c=134.1a
    C24 (VSS!\#1 3) capacitor c=249.65a
    C19 (B VSS!) capacitor c=3.93913e-18
    C38 (Y\#3 B) capacitor c=185.018a
    C45 (3 B) capacitor c=2.21732e-15
    C47 (B\#3 3) capacitor c=1.42555e-15
    C21 (VSS!\#1 B\#3) capacitor c=95.5396a
    C39 (Y\#3 B\#3) capacitor c=449.24a
    Rc7 (Y\#3 Y\#5) resistor r=5.0981
    Rs1 (3 VSS!) resistor r=50
    Rc9 (Y Y\#1) resistor r=1.603
    Rc8 (Y\#1 Y\#3) resistor r=7.1435
    Rd6 (Y Y\#3) resistor r=414.3m
    Rc14 (VDD!\#1 VDD!) resistor r=1.4545
    Rc4 (net9 net9\#2) resistor r=2.7059
    Rc2 (B\#1 B\#2) resistor r=744.2584
    Rd1 (A\#4 A\#5) resistor r=657.2891
    Rd2 (A\#5 A) resistor r=5.07
    Rc1 (A\#5 A\#6) resistor r=957.2891
    Rc6 (Y\#3 Y\#4) resistor r=5.3575
    Rd5 (VSS! VSS!\#2) resistor r=5.8178
    Rc5 (VSS!\#1 VSS!\#2) resistor r=71.8528
    Rd4 (VSS! VSS!\#1) resistor r=5.9341
    Rc3 (B\#2 B) resistor r=750.9302
    Rd3 (B\#2 B\#3) resistor r=1044.2584
    MX3_M0_unmatched (Y\#5 B\#3 VSS!\#1 VSS!\#1) nch w=2e-06 l=1e-06 as=0 \
        ad=5e-12 ps=0 pd=9e-06 sa=2e-06 sb=2e-06
    MX2_M0_unmatched (Y\#4 A\#6 VSS!\#2 VSS!\#2) nch w=2e-06 l=1e-06 as=0 \
        ad=5e-12 ps=0 pd=9e-06 sa=2e-06 sb=2e-06
    MX5_M0_unmatched (Y\#1 B\#1 net9 net9) pch w=8e-06 l=1e-06 as=0 \
        ad=2e-11 ps=0 pd=2.1e-05 sa=2e-06 sb=2e-06
    MX4_M0_unmatched (net9\#2 A\#4 VDD!\#1 VDD!\#1) pch w=8e-06 l=1e-06 \
        as=0 ad=2e-11 ps=0 pd=2.1e-05 sa=2e-06 sb=2e-06
ends NOR2X1_analog_extracted
// End of subcircuit definition.

// Library name: KISTA_SOI_STDLIB
// Cell name: BUFX2
// View name: analog_extracted
subckt BUFX2_analog_extracted A Y
    Rc9 (VSS!\#1 VSS!) resistor r=2.8429
    Rc10 (VSS! VSS!\#2) resistor r=5.3217
    Rd3 (A\#3 A) resistor r=525.9402
    Rs1 (3 VSS!) resistor r=50
    Rc7 (VDD!\#1 VDD!) resistor r=1.6554
    Rc8 (VDD! VDD!\#2) resistor r=2.7842
    Rc6 (Y Y\#2) resistor r=1.4275
    Rc5 (Y Y\#1) resistor r=2.7225
    Rd4 (net6\#5 net6\#6) resistor r=444.2584
    Rd1 (A\#2 A\#3) resistor r=1044.2584
    Rc2 (net6\#6 net6\#7) resistor r=1044.2584
    Rd6 (net6\#6 net6) resistor r=370.9252
    Rc4 (net6 net6\#4) resistor r=10.4446
    Rd5 (net6 net6\#3) resistor r=19.9376
    Rc3 (net6\#4 net6\#3) resistor r=10.7147
    Rc1 (A\#3 A\#4) resistor r=1044.2584
    C4 (A VSS!) capacitor c=2.07322e-15
    C17 (3 VSS!) capacitor c=37.7107f
    C2 (VDD!\#1 VSS!) capacitor c=2.01573e-15
    C1 (VSS! VDD!) capacitor c=6.97565e-15
    C3 (VDD!\#2 VSS!) capacitor c=1.58248e-15
    C9 (Y\#2 VSS!) capacitor c=1.23476e-15
    C8 (Y VSS!) capacitor c=1.31357e-15
    C10 (Y\#1 VSS!) capacitor c=1.37661e-15
    C12 (net6\#5 VSS!) capacitor c=1.44955e-15
    C16 (net6\#6 VSS!) capacitor c=2.15027e-15
    C18 (X5_5 VSS!) capacitor c=1.34974e-15
    C19 (X4_5 VSS!) capacitor c=1.12619e-15
    C5 (A\#2 VSS!) capacitor c=1.97575e-15
    C7 (A\#3 VSS!) capacitor c=3.15649e-15
    C14 (net6\#4 VSS!) capacitor c=3.21343e-15
    C13 (net6\#7 VSS!) capacitor c=1.96573e-15
    C11 (net6 VSS!) capacitor c=1.84034e-15
    C15 (net6\#3 VSS!) capacitor c=960.965a
    C6 (A\#4 VSS!) capacitor c=1.83033e-15
    MX5_M0_unmatched (Y\#2 net6\#5 VDD!\#1 VDD!\#1) pch w=8e-06 l=1e-06 \
        as=0 ad=2e-11 ps=0 pd=2.1e-05 sa=2e-06 sb=2e-06
    MX4_M0_unmatched (net6\#4 A\#2 VDD!\#2 VDD!\#2) pch w=4e-06 l=1e-06 \
        as=0 ad=1e-11 ps=0 pd=1.3e-05 sa=2e-06 sb=2e-06
    MX3_M0_unmatched (Y\#1 net6\#7 VSS!\#1 VSS!\#1) nch w=4e-06 l=1e-06 \
        as=0 ad=1e-11 ps=0 pd=1.3e-05 sa=2e-06 sb=2e-06
    MX2_M0_unmatched (net6\#3 A\#4 VSS!\#2 VSS!\#2) nch w=2e-06 l=1e-06 \
        as=0 ad=5e-12 ps=0 pd=9e-06 sa=2e-06 sb=2e-06
ends BUFX2_analog_extracted
// End of subcircuit definition.

// Library name: KISTA_SOI_STDLIB
// Cell name: NAND2X1
// View name: analog_extracted
subckt NAND2X1_analog_extracted A Y B
    Rs1 (3 VSS!) resistor r=50
    Rc10 (VDD!\#1 VDD!\#2) resistor r=24.7053
    Rc16 (VSS!\#1 VSS!) resistor r=2.7536
    Rd1 (A\#4 A\#5) resistor r=1257.2892
    Rd2 (A\#5 A) resistor r=5.0588
    Rc1 (A\#5 A\#6) resistor r=657.2891
    Rd5 (VDD! VDD!\#2) resistor r=3.1463
    Rd4 (VDD! VDD!\#1) resistor r=3.2407
    Rc5 (Y\#3 Y\#5) resistor r=2.6231
    Rc2 (B\#1 B\#2) resistor r=1344.2584
    Rc9 (Y\#3 Y\#4) resistor r=2.8825
    Rc4 (net6 net6\#2) resistor r=5.075
    Rd6 (Y Y\#3) resistor r=351.3m
    Rc11 (Y Y\#1) resistor r=2.7184
    Rc12 (Y\#1 Y\#3) resistor r=35.1317
    Rd3 (B\#2 B\#3) resistor r=744.2584
    Rc3 (B\#2 B) resistor r=750.9427
    C17 (VDD!\#1 Y\#5) capacitor c=157.013a
    C19 (VDD!\#1 B\#1) capacitor c=162.775a
    C21 (VDD!\#1 3) capacitor c=50.589a
    C45 (B\#1 3) capacitor c=1.25679e-15
    C9 (B\#1 VSS!) capacitor c=2.16862e-18
    C12 (3 VSS!) capacitor c=7.52741e-15
    C1 (VDD!\#2 VSS!) capacitor c=11.004a
    C22 (VDD!\#2 3) capacitor c=4.99762e-15
    C2 (A VSS!) capacitor c=10.262a
    C29 (3 A) capacitor c=3.90838e-15
    C3 (A\#4 VSS!) capacitor c=3.38014e-18
    C16 (VDD!\#2 A\#4) capacitor c=197.16a
    C30 (A\#4 3) capacitor c=1.16761e-15
    C4 (VSS!\#1 A) capacitor c=22.1511a
    C13 (VSS!\#1 3) capacitor c=1.29653e-15
    C5 (VSS!\#1 A\#6) capacitor c=180.752a
    C31 (A\#6 3) capacitor c=1.09082e-15
    C6 (A\#5 VSS!) capacitor c=1.15266e-19
    C32 (A\#5 3) capacitor c=39.297a
    C26 (Y\#4 A) capacitor c=59.0578a
    C18 (VDD!\#2 Y\#4) capacitor c=151.553a
    C27 (Y\#4 A\#4) capacitor c=674.149a
    C28 (A\#5 Y\#4) capacitor c=4.57913e-19
    C34 (A\#4 X2_5) capacitor c=509.926a
    C24 (VDD!\#2 X2_5) capacitor c=348.531a
    C43 (Y\#4 X2_5) capacitor c=448.721a
    C20 (3 VDD!) capacitor c=2.2596e-15
    C23 (VDD!\#1 X3_5) capacitor c=184.072a
    C42 (Y\#5 X3_5) capacitor c=448.721a
    C49 (B\#1 X3_5) capacitor c=504.33a
    C37 (Y\#3 B\#1) capacitor c=766.338a
    C11 (B\#2 VSS!) capacitor c=5.01714e-18
    C38 (B\#2 Y\#3) capacitor c=603.712a
    C39 (Y\#3 3) capacitor c=5.66192e-15
    C47 (B\#2 3) capacitor c=3.00815e-15
    C41 (net6\#2 Y\#4) capacitor c=2.93542e-18
    C15 (VSS!\#1 net6\#2) capacitor c=88.9107a
    C33 (net6\#2 A\#6) capacitor c=138.973a
    C25 (A\#6 Y) capacitor c=2.6053e-18
    C7 (Y VSS!) capacitor c=25.0372a
    C51 (net6\#2 3) capacitor c=266.08a
    C14 (net6 VSS!) capacitor c=5.65898e-18
    C40 (net6 Y) capacitor c=83.1149a
    C50 (net6 3) capacitor c=243.228a
    C8 (B VSS!) capacitor c=3.93794e-18
    C10 (B\#3 VSS!) capacitor c=10.0461a
    C35 (B\#3 Y) capacitor c=199.606a
    C36 (Y\#3 B) capacitor c=195.609a
    C48 (B\#3 net6) capacitor c=138.05a
    C44 (3 B) capacitor c=2.20859e-15
    C46 (B\#3 3) capacitor c=1.20834e-15
    MX4_M0_unmatched (net6\#2 A\#6 VSS!\#1 VSS!\#1) nch w=4e-06 l=1e-06 \
        as=0 ad=1e-11 ps=0 pd=1.3e-05 sa=2e-06 sb=2e-06
    MX5_M0_unmatched (Y\#1 B\#3 net6 net6) nch w=4e-06 l=1e-06 as=0 \
        ad=1e-11 ps=0 pd=1.3e-05 sa=2e-06 sb=2e-06
    MX3_M0_unmatched (Y\#5 B\#1 VDD!\#1 VDD!\#1) pch w=4e-06 l=1e-06 as=0 \
        ad=1e-11 ps=0 pd=1.3e-05 sa=2e-06 sb=2e-06
    MX2_M0_unmatched (Y\#4 A\#4 VDD!\#2 VDD!\#2) pch w=4e-06 l=1e-06 as=0 \
        ad=1e-11 ps=0 pd=1.3e-05 sa=2e-06 sb=2e-06
ends NAND2X1_analog_extracted
// End of subcircuit definition.

// Library name: KISTA_SOI_STDLIB
// Cell name: DFFX1
// View name: analog_extracted
subckt DFFX1_analog_extracted Q D QN CK
    Rc49 (VSS!\#3 VSS!\#2312) resistor r=5.1645
    Rc8 (D D\#1) resistor r=5.0025
    Rc5 (n20\#2 n20\#5) resistor r=2.72
    Rd17 (VSS!\#8 VSS!\#2317) resistor r=5.1645
    Rc7 (n20\#2 n20\#3) resistor r=5.1631
    Rd14 (CK\#3 CK) resistor r=450.9377
    Rc58 (VSS! VSS!\#2310) resistor r=5.1886
    Rc32 (n30\#2 n30\#4) resistor r=5.1631
    Rc25 (mout\#3 mout\#8) resistor r=2.7181
    Rc61 (VSS!\#6 VSS!\#2315) resistor r=5.1645
    Rc20 (mout\#3 mout\#7) resistor r=5.2631
    Rc50 (VSS!\#5 VSS!\#2314) resistor r=5.1645
    Rc31 (n30\#8 n30) resistor r=80.464
    Rd2 (n30 n30\#2) resistor r=5.0795
    Rc33 (n30\#2 n30\#5) resistor r=2.7181
    Rc47 (QN QN\#3) resistor r=2.8181
    Rc46 (QN QN\#2) resistor r=5.1631
    Rd8 (VDD!\#1 VDD!\#2) resistor r=2.906
    Rd39 (net055\#5 net055\#6) resistor r=1014.2584
    Rs1 (10 VSS!) resistor r=50
    Rc83 (net055\#6 net055\#7) resistor r=1434.2584
    Rd35 (net055\#6 net055) resistor r=445.9252
    Rc41 (Q Q\#3) resistor r=2.7206
    Rc40 (Q Q\#2) resistor r=5.2606
    Rc68 (qbint\#7 qbint\#2311) resistor r=999.0477
    Rd7 (VDD!\#2 VDD!\#2312) resistor r=4.2474
    Rd9 (VDD!\#2312 VDD!\#4) resistor r=8.5777
    Rc64 (VDD!\#2 VDD!\#4) resistor r=0.621
    Rc53 (VDD!\#2 VDD!\#2311) resistor r=2.7095
    Rd25 (qbint\#5 qbint\#6) resistor r=1014.2584
    Rd24 (qbint\#6 qbint\#7) resistor r=1117.6837
    Rc78 (qbint\#6 qbint\#9) resistor r=1434.2584
    Rc73 (net055 net055\#4) resistor r=10.3451
    Rd34 (net055 net055\#3) resistor r=20.0314
    Rc57 (net055\#4 net055\#3) resistor r=10.8255
    Rd13 (VSS!\#1 VSS!\#2311) resistor r=151.663
    Rd15 (VSS!\#1 VSS!\#3) resistor r=5.7608
    Rc59 (VSS!\#2311 VSS!\#3) resistor r=5.5497
    Rd31 (qbint\#7 qbint\#2310) resistor r=1419.0477
    Rc79 (qbint\#7 qbint\#8) resistor r=2362.7004
    Rd4 (D\#2 D\#1) resistor r=777.2892
    Rd5 (D\#1 D\#3) resistor r=1347.2892
    Rd42 (VDD!\#8 VDD!\#2317) resistor r=2.7345
    Rc9 (net14 net14\#2) resistor r=5.1154
    Rc82 (CKbb\#8 CKbb\#2311) resistor r=463.6361
    Rc10 (net13 net13\#2) resistor r=10.1
    Rc51 (VSS! VSS!\#8) resistor r=409.6m
    Rb1 (CKb\#8 CKb\#2313) resistor r=538.6361
    Rd12 (CK\#2 CK\#3) resistor r=864.2584
    Rc48 (CK\#3 CK\#4) resistor r=1434.2584
    Rc63 (VDD! VDD!\#2310) resistor r=2.7636
    Rc55 (VDD! VDD!\#8) resistor r=408.5m
    Rc4 (VDD! VDD!\#2318) resistor r=5.6939
    Rd1 (VDD!\#8 VDD!\#2318) resistor r=5.6388
    Rb2 (CKb\#2310 CKb\#2314) resistor r=864.2584
    Rc67 (CKb\#4 CKb\#3) resistor r=10.7673
    Rd30 (CKb CKb\#3) resistor r=20.1588
    Rc77 (CKb CKb\#4) resistor r=10.3151
    Rd23 (CKb\#2310 CKb) resistor r=370.9252
    Rc76 (CKb\#9 CKb\#2310) resistor r=1434.2584
    Rd29 (CKb\#8 CKb\#9) resistor r=2928.0679
    Rc66 (CKb\#7 CKb\#8) resistor r=2988.5168
    Rd6 (VSS!\#8 VSS!\#2318) resistor r=10.2888
    Rc52 (VSS! VSS!\#2318) resistor r=10.7825
    Rc74 (CKbb\#2 CKbb\#4) resistor r=10.6105
    Rd40 (CKbb CKbb\#4) resistor r=21.8576
    Rc72 (CKbb CKbb\#2) resistor r=10.0081
    Rd33 (CKbb\#8 CKbb) resistor r=2001.5475
    Rd37 (CKbb\#7 CKbb\#8) resistor r=4188.5166
    Rc54 (VDD!\#4 VDD!\#2313) resistor r=2.7095
    Rc34 (net029 net029\#2) resistor r=5.075
    Rd26 (qbint\#8 qbint\#2313) resistor r=997.5659
    Rd36 (CKbb\#5 CKbb\#6) resistor r=3453.0679
    Rd38 (CKbb\#6 CKbb\#7) resistor r=1188.5167
    Rc81 (CKbb\#6 CKbb\#9) resistor r=3858.8735
    Rc71 (CKbb\#7 CKbb\#2310) resistor r=3991.2551
    Rc26 (n30\#2 n30\#2310) resistor r=3.9915
    Rc29 (n30\#2310 n30\#2313) resistor r=27.1489
    Rc30 (n30\#2 n30\#2313) resistor r=7.3129
    Rc35 (net028 net028\#2) resistor r=10.1
    Rc75 (CKb\#6 CKb\#5) resistor r=4728.0679
    Rb3 (CKb\#6 CKb\#7) resistor r=1188.5167
    Rd28 (CKb\#6 CKb\#2311) resistor r=3633.8735
    Rd22 (CKb\#7 CKb\#2312) resistor r=3766.2549
    Rc15 (net018 net018\#2) resistor r=5.075
    Rc65 (VDD!\#6 VDD!\#2315) resistor r=2.7095
    Rc12 (mout mout\#2) resistor r=1006.0318
    Rd43 (VDD!\#6 VDD!\#8) resistor r=0.621
    Rc2 (VDD!\#2316 VDD!\#8) resistor r=8.5777
    Rd41 (VDD!\#6 VDD!\#2316) resistor r=4.2474
    Rc56 (VDD!\#4 VDD!\#6) resistor r=835.5m
    Rd11 (VDD!\#4 VDD!\#2314) resistor r=3.7973
    Rd10 (VDD!\#2314 VDD!\#6) resistor r=11.5401
    Rc3 (n30\#7 n30\#8) resistor r=1006.0318
    Rc28 (n20\#6 n20\#7) resistor r=1014.2584
    Rc36 (n20\#7 n20\#2) resistor r=750.9252
    Rc37 (n20\#7 n20\#8) resistor r=1434.2584
    Rc38 (n20\#2 n20) resistor r=174.5m
    Rc6 (n20 n20\#2310) resistor r=3.7217
    Rc11 (n20 n20\#2312) resistor r=6.8186
    Rc14 (n20\#2310 n20\#2312) resistor r=32.8723
    Rc16 (net017 net017\#2) resistor r=10.1
    Rc21 (mout\#2 mout\#3) resistor r=47.964
    Rc22 (mout\#2 mout\#4) resistor r=1426.0319
    Rd18 (VSS!\#6 VSS!\#8) resistor r=607.4m
    Rc62 (VSS!\#2316 VSS!\#8) resistor r=15.9906
    Rd21 (VSS!\#6 VSS!\#2316) resistor r=7.918
    Rd16 (VSS!\#5 VSS!\#6) resistor r=596.2m
    Rc60 (VSS!\#3 VSS!\#5) resistor r=607.4m
    Rd19 (VSS!\#3 VSS!\#2313) resistor r=15.9906
    Rd20 (VSS!\#2313 VSS!\#5) resistor r=7.918
    Rd3 (n30\#8 n30\#9) resistor r=1426.0319
    Rc69 (qbint\#8 qbint\#2312) resistor r=1417.5659
    Rd27 (qbint\#8 qbint) resistor r=82.8419
    Rd32 (qbint qbint\#3) resistor r=20.215
    Rc80 (qbint qbint\#4) resistor r=10.4399
    Rc70 (qbint\#4 qbint\#3) resistor r=10.7906
    Rc23 (mout\#3 mout\#9) resistor r=3.611
    Rc17 (mout\#3 mout\#2311) resistor r=6.9897
    Rc24 (mout\#9 mout\#2311) resistor r=32.3608
    C4 (VSS! D) capacitor c=347.57a
    C11 (VSS! CK) capacitor c=1.94469e-15
    C9 (QN\#3 VSS!) capacitor c=1.77117e-15
    C8 (VSS! QN) capacitor c=2.99091e-15
    C10 (QN\#2 VSS!) capacitor c=880.953a
    C16 (VDD!\#1 VSS!) capacitor c=506.526a
    C65 (net055\#5 VSS!) capacitor c=921.882a
    C69 (10 VSS!) capacitor c=64.0779f
    C82 (21 VSS!) capacitor c=1.94456e-15
    C83 (X41_5 VSS!) capacitor c=1.14629e-15
    C84 (X40_5 VSS!) capacitor c=879.514a
    C85 (X39_5 VSS!) capacitor c=842.637a
    C86 (X38_5 VSS!) capacitor c=895.192a
    C87 (X37_5 VSS!) capacitor c=944.088a
    C88 (X36_5 VSS!) capacitor c=1.49854e-15
    C89 (X35_5 VSS!) capacitor c=1.38207e-15
    C90 (X34_5 VSS!) capacitor c=957.737a
    C91 (X33_5 VSS!) capacitor c=954.539a
    C92 (X32_5 VSS!) capacitor c=873.236a
    C93 (X31_5 VSS!) capacitor c=935.113a
    C94 (X30_5 VSS!) capacitor c=1.07878e-15
    C95 (X29_5 VSS!) capacitor c=1.23814e-15
    C96 (VDD!\#2 10) capacitor c=40.8588f
    C142 (net055\#5 10) capacitor c=978.96a
    C68 (net055\#6 VSS!) capacitor c=282.077a
    C146 (net055\#6 10) capacitor c=3.10866e-15
    C66 (net055\#7 VSS!) capacitor c=357.581a
    C143 (net055\#7 10) capacitor c=1.97197e-15
    C141 (10 net055) capacitor c=1.63853e-15
    C1 (VSS! Q) capacitor c=2.98659e-15
    C2 (Q\#3 VSS!) capacitor c=951.892a
    C3 (Q\#2 VSS!) capacitor c=1.14529e-15
    C18 (VDD!\#2312 VSS!) capacitor c=495.603a
    C57 (qbint\#2311 VSS!) capacitor c=962.419a
    C132 (qbint\#2311 10) capacitor c=991.562a
    C64 (qbint\#7 VSS!) capacitor c=1.64582e-15
    C140 (qbint\#7 10) capacitor c=6.03761e-15
    C17 (VDD!\#2311 VSS!) capacitor c=476.565a
    C56 (qbint\#5 VSS!) capacitor c=962.56a
    C67 (net055\#4 VSS!) capacitor c=1.27654e-15
    C131 (qbint\#5 10) capacitor c=991.231a
    C63 (qbint\#6 VSS!) capacitor c=609.929a
    C139 (qbint\#6 10) capacitor c=3.80757e-15
    C144 (net055\#4 10) capacitor c=2.15147e-15
    C59 (qbint\#9 VSS!) capacitor c=376.151a
    C134 (qbint\#9 10) capacitor c=2.01378e-15
    C145 (net055\#3 10) capacitor c=800.821a
    C60 (qbint\#2310 VSS!) capacitor c=376.011a
    C135 (qbint\#2310 10) capacitor c=2.01378e-15
    C7 (D\#1 VSS!) capacitor c=3.55126e-15
    C5 (D\#2 VSS!) capacitor c=1.63917e-15
    C6 (D\#3 VSS!) capacitor c=2.17038e-15
    C23 (VDD!\#2317 VSS!) capacitor c=568.817a
    C77 (net14\#2 VSS!) capacitor c=8.26e-16
    C76 (net14 VSS!) capacitor c=475.361a
    C39 (CKbb\#2311 VSS!) capacitor c=863.708a
    C112 (CKbb\#2311 10) capacitor c=773.645a
    C45 (CKbb\#8 VSS!) capacitor c=1.18828e-15
    C119 (CKbb\#8 10) capacitor c=6.87641e-15
    C122 (n20\#2 10) capacitor c=10.4793f
    C71 (net13\#2 VSS!) capacitor c=420.625a
    C70 (net13 VSS!) capacitor c=384.04a
    C31 (CKb\#2313 VSS!) capacitor c=248.461a
    C102 (CKb\#2313 10) capacitor c=1.42424e-15
    C36 (CKb\#8 VSS!) capacitor c=1.28355e-15
    C108 (CKb\#8 10) capacitor c=6.34425e-15
    C14 (CK\#3 VSS!) capacitor c=3.32019e-15
    C12 (CK\#2 VSS!) capacitor c=1.76017e-15
    C13 (CK\#4 VSS!) capacitor c=2.37844e-15
    C25 (VDD!\#2310 VSS!) capacitor c=727.308a
    C15 (VDD! VSS!) capacitor c=66.8392a
    C33 (CKb\#4 VSS!) capacitor c=1.6233e-15
    C104 (CKb\#4 10) capacitor c=1.839e-15
    C24 (VDD!\#2318 VSS!) capacitor c=585.67a
    C29 (CKb\#2314 VSS!) capacitor c=945.241a
    C42 (CKbb\#2 VSS!) capacitor c=2.38904e-15
    C100 (CKb\#2314 10) capacitor c=812.722a
    C37 (CKb\#2310 VSS!) capacitor c=263.047a
    C109 (CKb\#2310 10) capacitor c=2.85121e-15
    C115 (CKbb\#2 10) capacitor c=1.47464e-15
    C105 (CKb\#3 10) capacitor c=976.506a
    C97 (10 CKb) capacitor c=1.70562e-15
    C32 (CKb\#9 VSS!) capacitor c=1.05787e-15
    C103 (CKb\#9 10) capacitor c=4.67034e-15
    C35 (CKb\#7 VSS!) capacitor c=2.06769e-15
    C107 (CKb\#7 10) capacitor c=7.9493e-15
    C116 (CKbb\#4 10) capacitor c=1.55741e-15
    C110 (10 CKbb) capacitor c=3.6996e-15
    C44 (CKbb\#7 VSS!) capacitor c=2.22744e-15
    C118 (CKbb\#7 10) capacitor c=8.21978e-15
    C19 (VDD!\#2313 VSS!) capacitor c=1.11588e-15
    C58 (qbint\#2313 VSS!) capacitor c=840.916a
    C81 (net029\#2 VSS!) capacitor c=560.569a
    C80 (net029 VSS!) capacitor c=545.499a
    C133 (qbint\#2313 10) capacitor c=930.249a
    C38 (CKbb\#5 VSS!) capacitor c=1.08842e-15
    C111 (CKbb\#5 10) capacitor c=4.20519e-15
    C43 (CKbb\#6 VSS!) capacitor c=3.4661e-15
    C117 (CKbb\#6 10) capacitor c=7.68438e-15
    C40 (CKbb\#9 VSS!) capacitor c=2.51293e-15
    C41 (CKbb\#2310 VSS!) capacitor c=1.70374e-15
    C113 (CKbb\#9 10) capacitor c=4.58869e-15
    C114 (CKbb\#2310 10) capacitor c=4.96923e-15
    C55 (n30\#2 VSS!) capacitor c=7.81656e-15
    C129 (n30\#2 10) capacitor c=12.8619f
    C30 (CKb\#5 VSS!) capacitor c=1.18287e-15
    C74 (net028 VSS!) capacitor c=402.281a
    C75 (net028\#2 VSS!) capacitor c=415.914a
    C101 (CKb\#5 10) capacitor c=5.88243e-15
    C34 (CKb\#6 VSS!) capacitor c=1.50615e-15
    C106 (CKb\#6 10) capacitor c=9.21044e-15
    C27 (CKb\#2311 VSS!) capacitor c=3.00704e-15
    C28 (CKb\#2312 VSS!) capacitor c=1.81357e-15
    C98 (CKb\#2311 10) capacitor c=4.41876e-15
    C99 (CKb\#2312 10) capacitor c=4.52289e-15
    C78 (net018 VSS!) capacitor c=463.421a
    C79 (net018\#2 VSS!) capacitor c=456.596a
    C21 (VDD!\#2315 VSS!) capacitor c=725.755a
    C26 (VDD!\#6 VSS!) capacitor c=3.88751e-15
    C50 (mout VSS!) capacitor c=851.417a
    C124 (10 mout) capacitor c=919.597a
    C22 (VDD!\#2316 VSS!) capacitor c=638.419a
    C20 (VDD!\#2314 VSS!) capacitor c=936.943a
    C53 (n30\#7 VSS!) capacitor c=958.937a
    C62 (qbint\#4 VSS!) capacitor c=2.92544e-15
    C127 (n30\#7 10) capacitor c=893.338a
    C137 (qbint\#4 10) capacitor c=2.38132e-15
    C47 (n20\#6 VSS!) capacitor c=952.957a
    C52 (mout\#3 VSS!) capacitor c=8.12815e-15
    C120 (n20\#6 10) capacitor c=1.00511e-15
    C49 (n20\#7 VSS!) capacitor c=241.586a
    C123 (n20\#7 10) capacitor c=3.44683e-15
    C126 (mout\#3 10) capacitor c=10.8875f
    C46 (n20 VSS!) capacitor c=7.13546e-15
    C48 (n20\#8 VSS!) capacitor c=352.428a
    C121 (n20\#8 10) capacitor c=1.98471e-15
    C72 (net017 VSS!) capacitor c=588.67a
    C73 (net017\#2 VSS!) capacitor c=575.009a
    C51 (mout\#4 VSS!) capacitor c=232.808a
    C125 (mout\#4 10) capacitor c=1.93316e-15
    C61 (qbint\#2312 VSS!) capacitor c=233.255a
    C54 (n30\#9 VSS!) capacitor c=351.983a
    C128 (n30\#9 10) capacitor c=1.86673e-15
    C136 (qbint\#2312 10) capacitor c=1.92327e-15
    C130 (10 qbint) capacitor c=6.82658e-15
    C138 (qbint\#3 10) capacitor c=870.725a
    MX26_M0_unmatched (Q\#2 qbint\#2310 VSS!\#2312 VSS!\#2312) nch w=2e-06 \
        l=1e-06 as=0 ad=5e-12 ps=0 pd=9e-06 sa=2e-06 sb=2e-06
    MX17_M0_unmatched (net13\#2 D\#3 VSS!\#2317 VSS!\#2317) nch w=2e-06 \
        l=1e-06 as=0 ad=5e-12 ps=0 pd=9e-06 sa=2e-06 sb=2e-06
    MX18_M0_unmatched (n20\#3 CKb\#2313 net13 net13) nch w=2e-06 l=1e-06 \
        as=0 ad=5e-12 ps=0 pd=9e-06 sa=2e-06 sb=2e-06
    MX15_M0_unmatched (CKb\#3 CK\#4 VSS!\#2310 VSS!\#2310) nch w=2e-06 \
        l=1e-06 as=0 ad=5e-12 ps=0 pd=9e-06 sa=2e-06 sb=2e-06
    MX22_M0_unmatched (n30\#4 CKbb\#9 mout\#2311 mout\#2311) nch w=2e-06 \
        l=1e-06 as=0 ad=5e-12 ps=0 pd=9e-06 sa=2e-06 sb=2e-06
    MX20_M0_unmatched (net017\#2 mout\#4 VSS!\#2315 VSS!\#2315) nch \
        w=2e-06 l=1e-06 as=0 ad=5e-12 ps=0 pd=9e-06 sa=2e-06 sb=2e-06
    MX19_M0_unmatched (mout\#7 n20\#8 VSS!\#2316 VSS!\#2316) nch w=2e-06 \
        l=1e-06 as=0 ad=5e-12 ps=0 pd=9e-06 sa=2e-06 sb=2e-06
    MX23_M0_unmatched (qbint\#3 n30\#9 VSS!\#2314 VSS!\#2314) nch w=2e-06 \
        l=1e-06 as=0 ad=5e-12 ps=0 pd=9e-06 sa=2e-06 sb=2e-06
    MX28_M0_unmatched (QN\#2 net055\#7 VSS!\#1 VSS!\#1) nch w=2e-06 \
        l=1e-06 as=0 ad=5e-12 ps=0 pd=9e-06 sa=2e-06 sb=2e-06
    MX27_M0_unmatched (net055\#3 qbint\#9 VSS!\#2311 VSS!\#2311) nch \
        w=2e-06 l=1e-06 as=0 ad=5e-12 ps=0 pd=9e-06 sa=2e-06 sb=2e-06
    MX16_M0_unmatched (CKbb\#4 CKb\#9 VSS!\#2318 VSS!\#2318) nch w=2e-06 \
        l=1e-06 as=0 ad=5e-12 ps=0 pd=9e-06 sa=2e-06 sb=2e-06
    MX25_M0_unmatched (n30\#2313 CKb\#5 net028 net028) nch w=2e-06 l=1e-06 \
        as=0 ad=5e-12 ps=0 pd=9e-06 sa=2e-06 sb=2e-06
    MX21_M0_unmatched (n20\#2312 CKbb\#2310 net017 net017) nch w=2e-06 \
        l=1e-06 as=0 ad=5e-12 ps=0 pd=9e-06 sa=2e-06 sb=2e-06
    MX24_M0_unmatched (net028\#2 qbint\#2312 VSS!\#2313 VSS!\#2313) nch \
        w=2e-06 l=1e-06 as=0 ad=5e-12 ps=0 pd=9e-06 sa=2e-06 sb=2e-06
    MX32_M0_unmatched (n20\#5 CKbb\#2311 net14 net14) pch w=4e-06 l=1e-06 \
        as=0 ad=1e-11 ps=0 pd=1.3e-05 sa=2e-06 sb=2e-06
    MX33_M0_unmatched (mout\#8 n20\#6 VDD!\#2316 VDD!\#2316) pch w=4e-06 \
        l=1e-06 as=0 ad=1e-11 ps=0 pd=1.3e-05 sa=2e-06 sb=2e-06
    MM14 (n30\#5 CKb\#2311 mout\#9 mout\#9) pch w=4e-06 l=1e-06 as=0 \
        ad=1e-11 ps=0 pd=1.3e-05 sa=2e-06 sb=2e-06
    MX41_M0_unmatched (QN\#3 net055\#5 VDD!\#1 VDD!\#1) pch w=4e-06 \
        l=1e-06 as=0 ad=1e-11 ps=0 pd=1.3e-05 sa=2e-06 sb=2e-06
    MX39_M0_unmatched (Q\#3 qbint\#2311 VDD!\#2312 VDD!\#2312) pch w=4e-06 \
        l=1e-06 as=0 ad=1e-11 ps=0 pd=1.3e-05 sa=2e-06 sb=2e-06
    MX40_M0_unmatched (net055\#4 qbint\#5 VDD!\#2311 VDD!\#2311) pch \
        w=4e-06 l=1e-06 as=0 ad=1e-11 ps=0 pd=1.3e-05 sa=2e-06 sb=2e-06
    MX31_M0_unmatched (net14\#2 D\#2 VDD!\#2317 VDD!\#2317) pch w=4e-06 \
        l=1e-06 as=0 ad=1e-11 ps=0 pd=1.3e-05 sa=2e-06 sb=2e-06
    MX29_M0_unmatched (CKb\#4 CK\#2 VDD!\#2310 VDD!\#2310) pch w=4e-06 \
        l=1e-06 as=0 ad=1e-11 ps=0 pd=1.3e-05 sa=2e-06 sb=2e-06
    MX30_M0_unmatched (CKbb\#2 CKb\#2314 VDD!\#2318 VDD!\#2318) pch \
        w=4e-06 l=1e-06 as=0 ad=1e-11 ps=0 pd=1.3e-05 sa=2e-06 sb=2e-06
    MX37_M0_unmatched (net029\#2 qbint\#2313 VDD!\#2313 VDD!\#2313) pch \
        w=4e-06 l=1e-06 as=0 ad=1e-11 ps=0 pd=1.3e-05 sa=2e-06 sb=2e-06
    MX38_M0_unmatched (n30\#2310 CKbb\#5 net029 net029) pch w=4e-06 \
        l=1e-06 as=0 ad=1e-11 ps=0 pd=1.3e-05 sa=2e-06 sb=2e-06
    MX35_M0_unmatched (n20\#2310 CKb\#2312 net018 net018) pch w=4e-06 \
        l=1e-06 as=0 ad=1e-11 ps=0 pd=1.3e-05 sa=2e-06 sb=2e-06
    MX34_M0_unmatched (net018\#2 mout VDD!\#2315 VDD!\#2315) pch w=4e-06 \
        l=1e-06 as=0 ad=1e-11 ps=0 pd=1.3e-05 sa=2e-06 sb=2e-06
    MX36_M0_unmatched (qbint\#4 n30\#7 VDD!\#2314 VDD!\#2314) pch w=4e-06 \
        l=1e-06 as=0 ad=1e-11 ps=0 pd=1.3e-05 sa=2e-06 sb=2e-06
ends DFFX1_analog_extracted
// End of subcircuit definition.

// Library name: KISTA_SOI_STDLIB
// Cell name: TIEHI
// View name: analog_extracted
subckt TIEHI_analog_extracted Y
    C1 (VSS! VDD!) capacitor c=3.89589e-15
    C3 (Y VSS!) capacitor c=613.594a
    C5 (1 VSS!) capacitor c=18.0875f
    C2 (VDD!\#1 VSS!) capacitor c=1.55868e-15
    C4 (Y\#1 VSS!) capacitor c=431.394a
    C7 (net7\#3 VSS!) capacitor c=2.91025e-15
    C6 (net7 VSS!) capacitor c=4.05181e-15
    C10 (X1_5 VSS!) capacitor c=1.17984e-15
    C8 (net7\#4 VSS!) capacitor c=895.178a
    C9 (net7\#2 VSS!) capacitor c=412.611a
    Rc4 (VDD! VDD!\#1) resistor r=2.7927
    Rc2 (Y Y\#1) resistor r=2.54
    Rs1 (1 VSS!) resistor r=50
    Rc3 (VSS!\#1 VSS!) resistor r=5.3554
    Rd1 (net7\#3 net7) resistor r=1557.2892
    Rd2 (net7 net7\#4) resistor r=357.2892
    Rc1 (net7 net7\#2) resistor r=10.1279
    MX1_M0_unmatched (Y\#1 net7\#3 VDD!\#1 VDD!\#1) pch w=4e-06 l=1e-06 \
        as=0 ad=1e-11 ps=0 pd=1.3e-05 sa=2e-06 sb=2e-06
    MX0_M0_unmatched (net7\#2 net7\#4 VSS!\#1 VSS!\#1) nch w=2e-06 l=1e-06 \
        as=0 ad=5e-12 ps=0 pd=9e-06 sa=2e-06 sb=2e-06
ends TIEHI_analog_extracted
// End of subcircuit definition.

// Library name: KISTA_SOI_STDLIB
// Cell name: TIELO
// View name: analog_extracted
subckt TIELO_analog_extracted Y
    C1 (VSS! Y) capacitor c=898.28a
    C2 (VDD! VSS!) capacitor c=3.84372e-15
    C4 (1 VSS!) capacitor c=17.8343f
    C3 (VDD!\#1 VSS!) capacitor c=1.13107e-15
    C5 (net25 VSS!) capacitor c=562.423a
    C6 (net25\#3 VSS!) capacitor c=985.513a
    C8 (net25\#2 VSS!) capacitor c=4.44284e-15
    C7 (net25\#4 VSS!) capacitor c=2.57283e-15
    C9 (X1_4 VSS!) capacitor c=1.3251e-15
    Rc5 (Y\#1 Y) resistor r=5
    Rc7 (VSS! VSS!\#1) resistor r=5.3102
    Rc6 (VDD!\#1 VDD!) resistor r=2.7054
    Rs1 (1 VSS!) resistor r=50
    Rc1 (net25 net25\#2) resistor r=7.6529
    Rd1 (net25\#3 net25\#2) resistor r=357.2892
    Rd2 (net25\#2 net25\#4) resistor r=1827.2892
    MX1_M0_unmatched (net25 net25\#3 VDD!\#1 VDD!\#1) pch w=4e-06 l=1e-06 \
        as=0 ad=1e-11 ps=0 pd=1.3e-05 sa=2e-06 sb=2e-06
    MX0_M0_unmatched (Y\#1 net25\#4 VSS!\#1 VSS!\#1) nch w=2e-06 l=1e-06 \
        as=0 ad=5e-12 ps=0 pd=9e-06 sa=2e-06 sb=2e-06
ends TIELO_analog_extracted
// End of subcircuit definition.

// Library name: KISTA_SOI_STDLIB
// Cell name: MX2X1
// View name: analog_extracted
subckt MX2X1 Y S0 B A
    Rs1 (3 VSS!) resistor r=50
    Rc17 (B B\#2) resistor r=2.625
    Rc9 (SB\#8 SB\#3) resistor r=357.2892
    Rd6 (Y Y\#2) resistor r=3.316
    Rc13 (Y\#2 Y\#1) resistor r=20.6749
    Rd4 (Y Y\#1) resistor r=3.432
    Rc15 (Y Y\#4) resistor r=5.1188
    Rc16 (B B\#1) resistor r=5.35
    Rd3 (Y\#4 Y\#6) resistor r=435.1
    Rd5 (S0\#3 S0\#5) resistor r=988.6361
    Rc1 (S0\#3 S0\#2) resistor r=2478.0679
    Rc12 (Y Y\#6) resistor r=5.2212
    Rd2 (S0\#3 S0\#4) resistor r=1177.9113
    Rd8 (A A\#3) resistor r=2.8727
    Rc18 (VDD!\#1 VDD!) resistor r=2.7049
    Rc7 (SB\#3 SB\#4) resistor r=36.6526
    Rc2 (SB\#3 SB\#7) resistor r=6.964
    Rc8 (SB\#4 SB\#7) resistor r=3.1928
    Rd1 (A A\#2) resistor r=5.2386
    Rc6 (A\#3 A\#2) resistor r=461.4998
    Rc11 (S0\#4 S0\#7) resistor r=1027.5659
    Rc14 (S0\#4 S0) resistor r=125.3469
    Rd7 (S0\#4 S0\#6) resistor r=1327.5659
    Rc19 (VSS!\#1 VSS!) resistor r=5.1799
    Rc4 (SB\#7 SB\#6) resistor r=5
    Rc10 (SB\#2 SB\#7) resistor r=230.4m
    Rc5 (SB SB\#2) resistor r=362.2892
    C10 (Y\#2 SB\#8) capacitor c=202.925a
    C15 (Y\#2 3) capacitor c=1.19897e-15
    C32 (SB\#8 VSS!) capacitor c=10.0888a
    C37 (3 VSS!) capacitor c=7.01265e-15
    C67 (B\#2 SB\#8) capacitor c=201.528a
    C69 (B\#2 3) capacitor c=162.568a
    C87 (SB\#8 3) capacitor c=542.044a
    C1 (Y\#4 VSS!) capacitor c=37.2183a
    C16 (Y\#4 3) capacitor c=344.133a
    C6 (Y\#2 B) capacitor c=193.079a
    C68 (3 B) capacitor c=1.93074e-15
    C11 (Y\#2 SB\#3) capacitor c=147.658a
    C33 (SB\#3 VSS!) capacitor c=2.19393e-18
    C88 (SB\#3 3) capacitor c=3.30954e-15
    C91 (SB\#8 X8_5) capacitor c=510.353a
    C19 (Y\#2 X8_5) capacitor c=304.1a
    C71 (B\#2 X8_5) capacitor c=405.588a
    C92 (SB\#3 X8_5) capacitor c=44.2344a
    C66 (B\#2 VDD!) capacitor c=13.9618a
    C29 (VDD! VSS!) capacitor c=5.26279e-18
    C72 (SB\#3 VDD!) capacitor c=198.64a
    C75 (3 VDD!) capacitor c=6.98798e-15
    C14 (3 Y) capacitor c=1.48352e-15
    C17 (Y\#1 3) capacitor c=132.998a
    C2 (S0\#2 Y) capacitor c=316.203a
    C24 (S0\#2 VSS!) capacitor c=10.3825a
    C60 (S0\#2 3) capacitor c=2.90358e-15
    C3 (Y\#1 S0\#5) capacitor c=146.339a
    C22 (S0\#5 VSS!) capacitor c=6.78987e-18
    C51 (SB\#3 S0\#5) capacitor c=30.0242a
    C58 (S0\#5 3) capacitor c=1.01779e-15
    C4 (S0\#3 Y) capacitor c=603.317a
    C27 (S0\#3 VSS!) capacitor c=12.9544a
    C40 (S0\#3 B) capacitor c=85.6715a
    C5 (B\#1 Y) capacitor c=193.638a
    C28 (B\#1 VSS!) capacitor c=20.5151a
    C39 (B\#1 S0\#2) capacitor c=315.634a
    C62 (S0\#3 3) capacitor c=5.09998e-15
    C70 (B\#1 3) capacitor c=1.63293e-15
    C18 (Y\#6 3) capacitor c=271.776a
    C45 (S0\#2 A) capacitor c=7.15588e-18
    C7 (A Y) capacitor c=35.7626a
    C30 (A VSS!) capacitor c=11.173a
    C49 (S0\#3 A) capacitor c=698.29a
    C50 (S0\#4 A) capacitor c=1.64809e-19
    C63 (S0\#4 3) capacitor c=208.148a
    C82 (3 A) capacitor c=2.1403e-15
    C8 (Y\#1 A\#3) capacitor c=98.5409a
    C46 (A\#3 S0\#5) capacitor c=230.062a
    C83 (A\#3 3) capacitor c=857.375a
    C20 (Y\#1 X7_5) capacitor c=155.064a
    C64 (S0\#5 X7_5) capacitor c=525.352a
    C85 (A\#3 X7_5) capacitor c=163.189a
    C53 (SB\#4 S0\#5) capacitor c=38.9624a
    C56 (S0\#4 SB\#4) capacitor c=32.5346a
    C73 (SB\#4 VDD!) capacitor c=165.746a
    C43 (S0\#4 VDD!\#1) capacitor c=1.54616e-19
    C74 (VDD!\#1 SB\#4) capacitor c=134.303a
    C76 (VDD!\#1 3) capacitor c=587.376a
    C80 (SB\#4 A\#3) capacitor c=198.51a
    C90 (SB\#4 3) capacitor c=5.97486e-15
    C9 (Y\#6 A\#2) capacitor c=52.6563a
    C84 (A\#2 3) capacitor c=402.322a
    C47 (A\#3 S0\#7) capacitor c=4.67684e-18
    C23 (S0\#7 VSS!) capacitor c=1.45245e-18
    C42 (VDD!\#1 S0\#7) capacitor c=181.371a
    C54 (SB\#4 S0\#7) capacitor c=258.299a
    C59 (S0\#7 3) capacitor c=953.891a
    C65 (S0\#7 X6_5) capacitor c=515.374a
    C77 (VDD!\#1 X6_5) capacitor c=405.588a
    C93 (SB\#4 X6_5) capacitor c=349.29a
    C41 (VDD!\#1 S0) capacitor c=12.1866a
    C52 (SB\#4 S0) capacitor c=822.403a
    C21 (S0 VSS!) capacitor c=3.04742e-18
    C44 (A S0) capacitor c=3.96272e-18
    C81 (SB\#6 A) capacitor c=130.847a
    C35 (SB\#6 VSS!) capacitor c=92.8991a
    C57 (3 S0) capacitor c=5.29576e-15
    C25 (VSS!\#1 S0) capacitor c=6.73101e-18
    C26 (VSS!\#1 S0\#6) capacitor c=129.774a
    C36 (VSS!\#1 SB\#6) capacitor c=99.5506a
    C38 (VSS!\#1 3) capacitor c=903.485a
    C48 (A\#2 S0\#6) capacitor c=2.8299e-18
    C55 (SB\#6 S0\#6) capacitor c=239.053a
    C61 (S0\#6 3) capacitor c=1.802e-15
    C13 (Y\#6 SB\#2) capacitor c=25.0525a
    C34 (SB\#2 VSS!) capacitor c=127.201a
    C31 (SB VSS!) capacitor c=2.7597e-18
    C12 (Y\#6 SB) capacitor c=88.9633a
    C78 (A\#2 SB) capacitor c=175.359a
    C79 (A\#2 SB\#2) capacitor c=60.2108a
    C86 (3 SB) capacitor c=1.09967e-15
    C89 (SB\#2 3) capacitor c=2.37779e-15
    MX5_M0_unmatched (Y\#4 S0\#2 B\#1 B\#1) nch w=2e-06 l=1e-06 as=0 \
        ad=5e-12 ps=0 pd=9e-06 sa=2e-06 sb=2e-06
    MX3_M0_unmatched (SB\#6 S0\#6 VSS!\#1 VSS!\#1) nch w=2e-06 l=1e-06 \
        as=0 ad=5e-12 ps=0 pd=9e-06 sa=2e-06 sb=2e-06
    MX4_M0_unmatched (Y\#6 SB A\#2 A\#2) nch w=2e-06 l=1e-06 as=0 ad=5e-12 \
        ps=0 pd=9e-06 sa=2e-06 sb=2e-06
    MX8_M0_unmatched (Y\#2 SB\#8 B\#2 B\#2) pch w=4e-06 l=1e-06 as=0 \
        ad=1e-11 ps=0 pd=1.3e-05 sa=2e-06 sb=2e-06
    MX7_M0_unmatched (Y\#1 S0\#5 A\#3 A\#3) pch w=4e-06 l=1e-06 as=0 \
        ad=1e-11 ps=0 pd=1.3e-05 sa=2e-06 sb=2e-06
    MX6_M0_unmatched (SB\#4 S0\#7 VDD!\#1 VDD!\#1) pch w=4e-06 l=1e-06 \
        as=0 ad=1e-11 ps=0 pd=1.3e-05 sa=2e-06 sb=2e-06
ends MX2X1
// End of subcircuit definition.

// Library name: KISTA_SOI_STDLIB
// Cell name: DFFSRX1
// View name: analog_extracted
subckt DFFSRX1 QN RN SN CK Q D
    Rc10 (VSS!\#7 VSS!\#2317) resistor r=5.1795
    Rc62 (RNb\#2 RNb\#4) resistor r=5.05
    Rd6 (mout\#9 mout\#2314) resistor r=2.751
    Rc8 (n35\#2 n35\#3) resistor r=2.725
    Rd37 (RN\#3 RN) resistor r=450.9277
    Rc63 (RNb\#2 RNb\#5) resistor r=2.8481
    Rd28 (VSS!\#3 VSS!\#2313) resistor r=5.1795
    Rd24 (VSS!\#5 VSS!\#2315) resistor r=5.1795
    Rc26 (n35\#6 n35) resistor r=370.9252
    Rc29 (n35 n35\#2) resistor r=5.0625
    Rc16 (RNb RNb\#2) resistor r=5.2295
    Rc13 (RNb\#7 RNb) resistor r=445.9252
    Rc23 (n20 n20\#2) resistor r=479.5m
    Rc51 (n35\#2 n35\#4) resistor r=5.225
    Rc74 (QN QN\#3) resistor r=2.7981
    Rc73 (QN QN\#2) resistor r=5.1481
    Rc93 (qint\#5 qint\#6) resistor r=886.0318
    Rs1 (13 VSS!) resistor r=50
    Rd40 (qint\#6 qint\#7) resistor r=1336.0317
    Rc80 (qint\#6 qint) resistor r=80.464
    Rd42 (RN\#2 RN\#3) resistor r=1494.2584
    Rc96 (RN\#3 RN\#4) resistor r=744.2584
    Rd17 (VDD!\#9 VDD!\#21) resistor r=2.7295
    Rd25 (VSS! VSS!\#7) resistor r=918.7m
    Rd52 (SN\#6 SN\#9) resistor r=657.2891
    Rc78 (SN\#8 SN\#6) resistor r=1407.2892
    Rc92 (SN\#6 SN) resistor r=6.3279
    Rd48 (SN\#4 SN) resistor r=85.464
    Rd47 (SN\#4 SN\#5) resistor r=1336.0317
    Rc79 (SN\#4 SN\#3) resistor r=886.0318
    Rd22 (VDD!\#5 VDD!\#2317) resistor r=2.7295
    Rc101 (VDD!\#20 VDD!\#9) resistor r=5.6553
    Rc112 (VDD!\#7 VDD!\#20) resistor r=5.6553
    Rd32 (VDD!\#5 VDD!\#7) resistor r=835.2m
    Rd15 (VDD!\#7 VDD!\#9) resistor r=406.4m
    Rd13 (VSS!\#2316 VSS!\#7) resistor r=6.6519
    Rc117 (VSS!\#5 VSS!\#2316) resistor r=26.9971
    Rc107 (VSS!\#2314 VSS!\#5) resistor r=6.6519
    Rc104 (VSS!\#3 VSS!\#2314) resistor r=26.9971
    Rd27 (VSS!\#3 VSS!\#5) resistor r=1.0225
    Rc116 (VSS!\#1 VSS!\#3) resistor r=5.7758
    Rc115 (VSS!\#1 VSS!\#2312) resistor r=152.4989
    Rd30 (VSS!\#2312 VSS!\#3) resistor r=5.5647
    Rc106 (VSS!\#5 VSS!\#7) resistor r=1.0225
    Rd11 (qbint\#7 qbint\#2311) resistor r=1029.2584
    Rc94 (qint qint\#3) resistor r=20.2079
    Rd34 (qint qint\#4) resistor r=10.3891
    Rd41 (qint\#4 qint\#3) resistor r=10.7338
    Rc44 (qbint\#6 qbint\#7) resistor r=1209.2584
    Rc38 (qbint\#7 qbint\#8) resistor r=1122.2889
    Rd19 (VDD!\#1 VDD!\#2314) resistor r=46.3683
    Rd21 (VDD!\#1 VDD!\#3) resistor r=3.3325
    Rc109 (VDD!\#2314 VDD!\#3) resistor r=3.1087
    Rc110 (VDD!\#3 VDD!\#5) resistor r=696.2m
    Rc111 (VDD!\#5 VDD!\#2318) resistor r=3.8239
    Rc100 (VDD!\#2318 VDD!\#7) resistor r=11.6209
    Rd33 (VDD!\#7 VDD!\#2319) resistor r=2.7295
    Rc48 (n35\#5 n35\#6) resistor r=894.2584
    Rc31 (net402 net402\#2) resistor r=5.075
    Rc71 (RNb\#6 RNb\#7) resistor r=1794.2584
    Rc22 (n20\#2311 n20\#2312) resistor r=444.2584
    Rc67 (Q Q\#2) resistor r=5.2481
    Rc68 (Q Q\#3) resistor r=2.6981
    Rc65 (qbint\#8 qbint\#2312) resistor r=1012.5659
    Rc99 (VDD!\#3 VDD!\#2315) resistor r=2.7295
    Rd23 (VDD!\#3 VDD!\#2316) resistor r=2.7295
    Rd10 (qbint\#8 qbint\#2313) resistor r=1192.5658
    Rc49 (qbint\#8 qbint\#5) resistor r=120.3419
    Rc5 (qbint\#5 qbint) resistor r=11.8583
    Rc30 (qbint qbint\#3) resistor r=10.1826
    Rc17 (qbint\#5 qbint\#3) resistor r=24.4008
    Rc50 (qbint\#5 qbint\#9) resistor r=1945.9253
    Rc53 (n35\#6 n35\#7) resistor r=1344.2584
    Rc60 (n43 n43\#2) resistor r=5.075
    Rc25 (RNb\#2311 RNb\#2310) resistor r=5642.5259
    Rc61 (RNb\#2310 RNb\#2) resistor r=6.6779
    Rc69 (RNb\#2310 RNb\#2312) resistor r=357.2892
    Rc70 (RNb\#7 RNb\#8) resistor r=444.2584
    Rc4 (qbint\#9 qbint\#2314) resistor r=1209.2584
    Rc6 (qbint\#9 qbint\#2310) resistor r=1029.2584
    Rc84 (n41 n41\#4) resistor r=8.4739
    Rd43 (n41 n41\#2) resistor r=8.2271
    Rd38 (n41\#2 n41\#4) resistor r=7.2903
    Rb6 (CKbb\#5 CKbb\#6) resistor r=4128.0679
    Rc7 (n35\#2 n35\#8) resistor r=3.8422
    Rc9 (n35\#2310 n35\#8) resistor r=31.4397
    Rc28 (n35\#2 n35\#2310) resistor r=7.8599
    Rc87 (CKb\#6 CKb\#5) resistor r=6453.0674
    Rc82 (n40 n40\#2) resistor r=15.6067
    Rd36 (n40 n40\#4) resistor r=15.9189
    Rc97 (n40\#2 n40\#4) resistor r=14.8611
    Rd18 (n42 n42\#4) resistor r=16.0189
    Rd20 (n42\#4 n42\#3) resistor r=14.7418
    Rc85 (n42 n42\#3) resistor r=16.0189
    Rc98 (net426\#2 net426\#4) resistor r=14.7739
    Rd39 (net426 net426\#4) resistor r=16.1209
    Rc86 (net426 net426\#2) resistor r=15.8048
    Rc21 (n20\#2312 n20\#2313) resistor r=1794.2584
    Rc18 (n20\#2312 n20) resistor r=526.5627
    Rd9 (mout\#2313 mout\#2311) resistor r=152.1254
    Rd7 (mout\#2310 mout\#2313) resistor r=5.4627
    Rc39 (mout\#2310 mout\#2311) resistor r=5.3556
    Rc37 (mout\#2315 mout\#2310) resistor r=3.7419
    Rd55 (mout mout\#2315) resistor r=11.466
    Rd8 (mout mout\#2310) resistor r=1.9539
    Rc43 (mout\#2 mout) resistor r=5.15
    Rc41 (mout\#9 mout\#2310) resistor r=196.2m
    Rd54 (mout\#7 mout\#9) resistor r=2.8421
    Rc40 (mout\#6 mout\#7) resistor r=63.1446
    Rc36 (mout\#6 mout\#9) resistor r=5.7978
    Rd4 (CKb\#6 CKb\#2311) resistor r=463.6361
    Rb1 (CKb\#6 CKb\#7) resistor r=7188.5166
    Rd50 (CKbb\#6 CKbb\#8) resistor r=538.6361
    Rc76 (CKbb\#6 CKbb\#7) resistor r=7188.5166
    Rc113 (VDD!\#9 VDD!\#22) resistor r=2.7295
    Rd16 (VDD!\#9 VDD!\#2311) resistor r=696.2m
    Rc81 (D\#2 D\#3) resistor r=1494.2584
    Rd14 (VSS!\#7 VSS!\#2319) resistor r=24.2568
    Rd12 (VSS!\#7 VSS!\#2318) resistor r=5.1795
    Rc14 (n22 n22\#2) resistor r=5.075
    Rd2 (CK\#5 CK) resistor r=450.9252
    Rc35 (mout\#3 mout\#2) resistor r=357.2892
    Rd53 (mout\#2 mout\#4) resistor r=1707.2892
    Rc95 (D\#3 D) resistor r=450.9252
    Rd5 (CKb\#7 CKb\#2312) resistor r=463.6361
    Rc75 (CKb\#7 CKb\#8) resistor r=1788.5167
    Rd29 (VSS! VSS!\#2311) resistor r=5.3602
    Rb4 (CKbb\#9 CKbb\#7) resistor r=538.6361
    Rd46 (CKbb\#7 CKbb) resistor r=3201.5476
    Rc103 (VSS! VSS!\#20) resistor r=5.1795
    Rd1 (CK\#4 CK\#5) resistor r=894.2584
    Rd3 (CK\#5 CK\#6) resistor r=1344.2584
    Rc118 (VDD! VDD!\#2313) resistor r=2.8102
    Rc114 (VDD! VDD!\#24) resistor r=4.5653
    Rc102 (VDD! VDD!\#2311) resistor r=328.1m
    Rd31 (VDD!\#2311 VDD!\#23) resistor r=2.7295
    Rd26 (VDD!\#2311 VDD!\#24) resistor r=7.276
    Rc11 (n31 n31\#2) resistor r=5.075
    Rb7 (CKb\#8 CKb\#2313) resistor r=3481.2549
    Rc46 (n20\#3 n20\#8) resistor r=57.6422
    Rc20 (n20\#2 n20\#3) resistor r=2.742
    Rc19 (n20\#2 n20\#8) resistor r=2.838
    Rb2 (CKb\#2310 CKb\#2314) resistor r=894.2584
    Rc12 (n30 n30\#2) resistor r=10.1
    Rc45 (VSS! VSS!\#2319) resistor r=6.8352
    Rd35 (D\#3 D\#4) resistor r=744.2584
    Rc15 (n21 n21\#2) resistor r=10.1
    Rd44 (CKb\#8 CKb\#9) resistor r=2253.0679
    Rc88 (CKb\#9 CKb\#2310) resistor r=1344.2584
    Rd49 (CKb\#2310 CKb) resistor r=520.9252
    Rc89 (CKb CKb\#4) resistor r=10.2944
    Rd51 (CKb\#4 CKb\#3) resistor r=10.7685
    Rb5 (CKb CKb\#3) resistor r=20.0239
    Rc64 (n20\#2 n20\#5) resistor r=5.6398
    Rc52 (n20\#2 n20\#7) resistor r=5.7526
    Rc47 (n20\#5 n20\#7) resistor r=89.0263
    Rc90 (CKbb\#9 CKbb\#2310) resistor r=3185.2375
    Rd45 (CKbb\#2 CKbb\#4) resistor r=10.5956
    Rc91 (CKbb CKbb\#2) resistor r=10.0124
    Rb3 (CKbb CKbb\#4) resistor r=21.827
    C4 (VSS! RN) capacitor c=2.01993e-15
    C166 (n20\#2 13) capacitor c=9.81842e-15
    C2 (QN\#3 VSS!) capacitor c=1.66137e-15
    C1 (VSS! QN) capacitor c=2.82159e-15
    C3 (QN\#2 VSS!) capacitor c=796.665a
    C20 (VDD!\#1 VSS!) capacitor c=518.351a
    C93 (qint\#5 VSS!) capacitor c=1.66251e-15
    C95 (13 VSS!) capacitor c=105.3f
    C112 (X64_5 VSS!) capacitor c=1.12526e-15
    C113 (X63_5 VSS!) capacitor c=858.476a
    C114 (X62_5 VSS!) capacitor c=905.021a
    C115 (X61_5 VSS!) capacitor c=880.293a
    C116 (X60_5 VSS!) capacitor c=1.39561e-15
    C117 (X59_5 VSS!) capacitor c=1.53617e-15
    C118 (X58_5 VSS!) capacitor c=840.708a
    C119 (X57_5 VSS!) capacitor c=924.1a
    C120 (X56_5 VSS!) capacitor c=990.63a
    C121 (X55_5 VSS!) capacitor c=1.04247e-15
    C122 (X54_5 VSS!) capacitor c=898.72a
    C123 (X53_5 VSS!) capacitor c=1.01913e-15
    C124 (X52_5 VSS!) capacitor c=883.756a
    C125 (X51_5 VSS!) capacitor c=875.116a
    C126 (X50_5 VSS!) capacitor c=1.01481e-15
    C127 (X49_5 VSS!) capacitor c=793.606a
    C128 (X48_5 VSS!) capacitor c=861.596a
    C129 (X47_5 VSS!) capacitor c=1.10613e-15
    C130 (X46_5 VSS!) capacitor c=1.26436e-15
    C94 (qint\#7 VSS!) capacitor c=2.12734e-15
    C92 (qint VSS!) capacitor c=8.61394e-15
    C7 (RN\#3 VSS!) capacitor c=3.15723e-15
    C5 (RN\#2 VSS!) capacitor c=2.63023e-15
    C6 (RN\#4 VSS!) capacitor c=1.55499e-15
    C28 (VDD!\#21 VSS!) capacitor c=1.29663e-15
    C33 (VDD!\#9 VSS!) capacitor c=5.92544e-15
    C73 (RNb\#2 VSS!) capacitor c=10.2617f
    C162 (RNb\#2 13) capacitor c=8.60879e-15
    C8 (VSS! SN) capacitor c=6.48543e-15
    C14 (13 SN) capacitor c=5.92991e-15
    C9 (SN\#8 VSS!) capacitor c=928.828a
    C15 (SN\#8 13) capacitor c=1.48395e-15
    C10 (SN\#3 VSS!) capacitor c=1.04577e-15
    C16 (SN\#3 13) capacitor c=769.688a
    C11 (SN\#9 VSS!) capacitor c=321.49a
    C17 (SN\#9 13) capacitor c=1.07426e-15
    C12 (SN\#5 VSS!) capacitor c=882.644a
    C18 (SN\#5 13) capacitor c=1.64363e-15
    C13 (SN\#6 VSS!) capacitor c=977.799a
    C19 (SN\#6 13) capacitor c=3.71205e-15
    C24 (VDD!\#2317 VSS!) capacitor c=665.095a
    C27 (VDD!\#20 VSS!) capacitor c=1.3439e-15
    C86 (qbint\#2311 VSS!) capacitor c=323.188a
    C175 (qbint\#2311 13) capacitor c=1.56763e-15
    C90 (qbint\#7 VSS!) capacitor c=334.071a
    C179 (qbint\#7 13) capacitor c=3.65254e-15
    C21 (VDD!\#2314 VSS!) capacitor c=475.65a
    C83 (qbint\#6 VSS!) capacitor c=984.82a
    C172 (qbint\#6 13) capacitor c=1.20859e-15
    C34 (VDD!\#3 13) capacitor c=54.1101f
    C25 (VDD!\#2318 VSS!) capacitor c=564.797a
    C26 (VDD!\#2319 VSS!) capacitor c=651.562a
    C79 (n35\#5 VSS!) capacitor c=941.693a
    C168 (n35\#5 13) capacitor c=909.128a
    C82 (n35\#6 VSS!) capacitor c=267.706a
    C171 (n35\#6 13) capacitor c=2.72188e-15
    C69 (RNb\#6 VSS!) capacitor c=1.47203e-15
    C108 (net402\#2 VSS!) capacitor c=515.004a
    C107 (net402 VSS!) capacitor c=456.903a
    C158 (RNb\#6 13) capacitor c=1.85298e-15
    C74 (RNb\#7 VSS!) capacitor c=797.618a
    C163 (RNb\#7 13) capacitor c=2.70405e-15
    C76 (n20\#2311 VSS!) capacitor c=858.717a
    C164 (n20\#2311 13) capacitor c=372.875a
    C78 (n20\#2312 VSS!) capacitor c=774.118a
    C167 (n20\#2312 13) capacitor c=2.86139e-15
    C41 (Q\#2 VSS!) capacitor c=1.08536e-15
    C39 (VSS! Q) capacitor c=2.78028e-15
    C40 (Q\#3 VSS!) capacitor c=1.0105e-15
    C87 (qbint\#2312 VSS!) capacitor c=313.587a
    C176 (qbint\#2312 13) capacitor c=1.48459e-15
    C22 (VDD!\#2315 VSS!) capacitor c=551.512a
    C23 (VDD!\#2316 VSS!) capacitor c=1.22981e-15
    C84 (qbint\#2313 VSS!) capacitor c=968.478a
    C173 (qbint\#2313 13) capacitor c=1.08054e-15
    C89 (qbint\#5 VSS!) capacitor c=8.40847e-15
    C178 (qbint\#5 13) capacitor c=12.3196f
    C80 (n35\#7 VSS!) capacitor c=416.618a
    C91 (qbint\#9 VSS!) capacitor c=607.971a
    C169 (n35\#7 13) capacitor c=1.76607e-15
    C81 (n35\#2 VSS!) capacitor c=7.83341e-15
    C170 (n35\#2 13) capacitor c=10.5665f
    C180 (qbint\#9 13) capacitor c=4.53833e-15
    C68 (RNb\#2311 VSS!) capacitor c=2.24681e-15
    C110 (n43 VSS!) capacitor c=642.516a
    C111 (n43\#2 VSS!) capacitor c=774.847a
    C157 (RNb\#2311 13) capacitor c=6.38278e-15
    C72 (RNb\#2310 VSS!) capacitor c=2.75071e-15
    C161 (RNb\#2310 13) capacitor c=7.12744e-15
    C70 (RNb\#2312 VSS!) capacitor c=231.827a
    C71 (RNb\#8 VSS!) capacitor c=263.19a
    C159 (RNb\#2312 13) capacitor c=754.704a
    C160 (RNb\#8 13) capacitor c=820.676a
    C85 (qbint\#2314 VSS!) capacitor c=852.527a
    C109 (n41 VSS!) capacitor c=6.10179e-15
    C174 (qbint\#2314 13) capacitor c=1.20122e-15
    C88 (qbint\#2310 VSS!) capacitor c=631.315a
    C177 (qbint\#2310 13) capacitor c=1.43352e-15
    C58 (CKbb\#5 VSS!) capacitor c=2.38532e-15
    C145 (CKbb\#5 13) capacitor c=4.68619e-15
    C62 (CKbb\#6 VSS!) capacitor c=2.04047e-15
    C151 (CKbb\#6 13) capacitor c=12.2054f
    C49 (CKb\#5 VSS!) capacitor c=3.21944e-15
    C135 (CKb\#5 13) capacitor c=7.84589e-15
    C53 (CKb\#6 VSS!) capacitor c=5.18582e-15
    C140 (CKb\#6 13) capacitor c=14.439f
    C101 (n42 VSS!) capacitor c=8.39376e-15
    C102 (n40\#2 VSS!) capacitor c=4.89485e-15
    C100 (net426\#2 VSS!) capacitor c=7.92832e-15
    C77 (n20\#2313 VSS!) capacitor c=473.54a
    C165 (n20\#2313 13) capacitor c=2.26116e-15
    C75 (n20 VSS!) capacitor c=6.82629e-15
    C67 (mout\#2310 VSS!) capacitor c=16.3767f
    C156 (mout\#2310 13) capacitor c=11.7631f
    C66 (mout\#2 VSS!) capacitor c=73.0588a
    C155 (mout\#2 13) capacitor c=3.47978e-15
    C46 (CKb\#2311 VSS!) capacitor c=950.378a
    C60 (CKbb\#8 VSS!) capacitor c=203.257a
    C132 (CKb\#2311 13) capacitor c=521.272a
    C54 (CKb\#7 VSS!) capacitor c=2.22482e-15
    C141 (CKb\#7 13) capacitor c=9.6032e-15
    C147 (CKbb\#8 13) capacitor c=991.537a
    C63 (CKbb\#7 VSS!) capacitor c=2.74595e-15
    C152 (CKbb\#7 13) capacitor c=11.7008f
    C29 (VDD!\#22 VSS!) capacitor c=1.37853e-15
    C43 (D\#2 VSS!) capacitor c=2.91751e-15
    C105 (n22 VSS!) capacitor c=626.151a
    C35 (VSS! CK) capacitor c=1.96264e-15
    C42 (D VSS!) capacitor c=2.17788e-15
    C59 (CKbb\#9 VSS!) capacitor c=1.82744e-15
    C106 (n22\#2 VSS!) capacitor c=624.259a
    C146 (CKbb\#9 13) capacitor c=3.66044e-15
    C30 (VDD!\#23 VSS!) capacitor c=640.083a
    C31 (VDD!\#24 VSS!) capacitor c=618.283a
    C32 (VDD!\#2313 VSS!) capacitor c=730.839a
    C38 (CK\#5 VSS!) capacitor c=3.22621e-15
    C36 (CK\#4 VSS!) capacitor c=1.79689e-15
    C37 (CK\#6 VSS!) capacitor c=2.26757e-15
    C52 (CKb\#4 VSS!) capacitor c=1.60633e-15
    C138 (CKb\#4 13) capacitor c=1.80237e-15
    C64 (mout\#3 VSS!) capacitor c=784.457a
    C104 (n31\#2 VSS!) capacitor c=1.30937e-15
    C103 (n31 VSS!) capacitor c=579.612a
    C153 (mout\#3 13) capacitor c=288.287a
    C65 (mout\#4 VSS!) capacitor c=251.865a
    C154 (mout\#4 13) capacitor c=2.32806e-15
    C47 (CKb\#2313 VSS!) capacitor c=984.995a
    C133 (CKb\#2313 13) capacitor c=4.21182e-15
    C55 (CKb\#8 VSS!) capacitor c=1.45979e-15
    C142 (CKb\#8 13) capacitor c=7.70565e-15
    C48 (CKb\#2314 VSS!) capacitor c=936.399a
    C134 (CKb\#2314 13) capacitor c=830.923a
    C56 (CKb\#2310 VSS!) capacitor c=245.525a
    C143 (CKb\#2310 13) capacitor c=2.95126e-15
    C149 (CKbb\#2 13) capacitor c=1.40435e-15
    C97 (n30\#2 VSS!) capacitor c=544.708a
    C96 (n30 VSS!) capacitor c=655.871a
    C44 (D\#4 VSS!) capacitor c=1.44251e-15
    C45 (D\#3 VSS!) capacitor c=3.09893e-15
    C98 (n21 VSS!) capacitor c=368.445a
    C99 (n21\#2 VSS!) capacitor c=368.834a
    C50 (CKb\#2312 VSS!) capacitor c=248.616a
    C136 (CKb\#2312 13) capacitor c=1.236e-15
    C51 (CKb\#9 VSS!) capacitor c=556.747a
    C137 (CKb\#9 13) capacitor c=3.99954e-15
    C131 (13 CKb) capacitor c=1.70037e-15
    C139 (CKb\#3 13) capacitor c=908.383a
    C61 (CKbb\#2310 VSS!) capacitor c=314.991a
    C148 (CKbb\#2310 13) capacitor c=4.40882e-15
    C57 (CKbb VSS!) capacitor c=2.43204e-15
    C144 (13 CKbb) capacitor c=4.98606e-15
    C150 (CKbb\#4 13) capacitor c=1.50684e-15
    MX33_M0_unmatched (RNb\#4 RN\#4 VSS!\#2317 VSS!\#2317) nch w=2e-06 \
        l=1e-06 as=0 ad=5e-12 ps=0 pd=9e-06 sa=2e-06 sb=2e-06
    MX43_M0_unmatched (Q\#2 qbint\#2312 VSS!\#2313 VSS!\#2313) nch w=2e-06 \
        l=1e-06 as=0 ad=5e-12 ps=0 pd=9e-06 sa=2e-06 sb=2e-06
    MX38_M0_unmatched (qbint\#3 n35\#7 VSS!\#2315 VSS!\#2315) nch w=2e-06 \
        l=1e-06 as=0 ad=5e-12 ps=0 pd=9e-06 sa=2e-06 sb=2e-06
    MX37_M0_unmatched (n35\#4 CKbb\#8 mout\#6 mout\#6) nch w=2e-06 l=1e-06 \
        as=0 ad=5e-12 ps=0 pd=9e-06 sa=2e-06 sb=2e-06
    MX45_M0_unmatched (QN\#2 qint\#7 VSS!\#1 VSS!\#1) nch w=2e-06 l=1e-06 \
        as=0 ad=5e-12 ps=0 pd=9e-06 sa=2e-06 sb=2e-06
    MX39_M0_unmatched (n42\#3 SN\#9 VSS!\#2314 VSS!\#2314) nch w=2e-06 \
        l=1e-06 as=0 ad=5e-12 ps=0 pd=9e-06 sa=2e-06 sb=2e-06
    MX34_M0_unmatched (net426\#4 SN\#5 VSS!\#2316 VSS!\#2316) nch w=2e-06 \
        l=1e-06 as=0 ad=5e-12 ps=0 pd=9e-06 sa=2e-06 sb=2e-06
    MX44_M0_unmatched (qint\#3 qbint\#2311 VSS!\#2312 VSS!\#2312) nch \
        w=2e-06 l=1e-06 as=0 ad=5e-12 ps=0 pd=9e-06 sa=2e-06 sb=2e-06
    MX42_M0_unmatched (n35\#2310 CKb\#5 n40 n40) nch w=2e-06 l=1e-06 as=0 \
        ad=5e-12 ps=0 pd=9e-06 sa=2e-06 sb=2e-06
    MX41_M0_unmatched (n40\#2 qbint\#2310 n42 n42) nch w=2e-06 l=1e-06 \
        as=0 ad=5e-12 ps=0 pd=9e-06 sa=2e-06 sb=2e-06
    MX40_M0_unmatched (n40\#4 RNb\#2312 n42\#4 n42\#4) nch w=2e-06 l=1e-06 \
        as=0 ad=5e-12 ps=0 pd=9e-06 sa=2e-06 sb=2e-06
    MX35_M0_unmatched (mout\#2311 RNb\#8 net426\#2 net426\#2) nch w=2e-06 \
        l=1e-06 as=0 ad=5e-12 ps=0 pd=9e-06 sa=2e-06 sb=2e-06
    MX36_M0_unmatched (mout\#2313 n20\#2313 net426 net426) nch w=2e-06 \
        l=1e-06 as=0 ad=5e-12 ps=0 pd=9e-06 sa=2e-06 sb=2e-06
    MX32_M0_unmatched (n21 D\#4 VSS!\#2318 VSS!\#2318) nch w=2e-06 l=1e-06 \
        as=0 ad=5e-12 ps=0 pd=9e-06 sa=2e-06 sb=2e-06
    MX27_M0_unmatched (CKb\#3 CK\#6 VSS!\#2311 VSS!\#2311) nch w=2e-06 \
        l=1e-06 as=0 ad=5e-12 ps=0 pd=9e-06 sa=2e-06 sb=2e-06
    MX28_M0_unmatched (CKbb\#4 CKb\#9 VSS!\#20 VSS!\#20) nch w=2e-06 \
        l=1e-06 as=0 ad=5e-12 ps=0 pd=9e-06 sa=2e-06 sb=2e-06
    MX29_M0_unmatched (n30\#2 mout\#4 VSS!\#2319 VSS!\#2319) nch w=2e-06 \
        l=1e-06 as=0 ad=5e-12 ps=0 pd=9e-06 sa=2e-06 sb=2e-06
    MX31_M0_unmatched (n20\#5 CKb\#2312 n21\#2 n21\#2) nch w=2e-06 l=1e-06 \
        as=0 ad=5e-12 ps=0 pd=9e-06 sa=2e-06 sb=2e-06
    MX30_M0_unmatched (n20\#7 CKbb\#2310 n30 n30) nch w=2e-06 l=1e-06 as=0 \
        ad=5e-12 ps=0 pd=9e-06 sa=2e-06 sb=2e-06
    MX56_M0_unmatched (n35\#3 CKb\#2311 mout\#2314 mout\#2314) pch w=4e-06 \
        l=1e-06 as=0 ad=1e-11 ps=0 pd=1.3e-05 sa=2e-06 sb=2e-06
    MX52_M0_unmatched (RNb\#5 RN\#2 VDD!\#21 VDD!\#21) pch w=4e-06 l=1e-06 \
        as=0 ad=1e-11 ps=0 pd=1.3e-05 sa=2e-06 sb=2e-06
    MX64_M0_unmatched (QN\#3 qint\#5 VDD!\#1 VDD!\#1) pch w=4e-06 l=1e-06 \
        as=0 ad=1e-11 ps=0 pd=1.3e-05 sa=2e-06 sb=2e-06
    MX58_M0_unmatched (n41\#4 SN\#8 VDD!\#2317 VDD!\#2317) pch w=4e-06 \
        l=1e-06 as=0 ad=1e-11 ps=0 pd=1.3e-05 sa=2e-06 sb=2e-06
    MX53_M0_unmatched (mout\#2315 SN\#3 VDD!\#20 VDD!\#20) pch w=4e-06 \
        l=1e-06 as=0 ad=1e-11 ps=0 pd=1.3e-05 sa=2e-06 sb=2e-06
    MX63_M0_unmatched (qint\#4 qbint\#6 VDD!\#2314 VDD!\#2314) pch w=4e-06 \
        l=1e-06 as=0 ad=1e-11 ps=0 pd=1.3e-05 sa=2e-06 sb=2e-06
    MX57_M0_unmatched (qbint n35\#5 VDD!\#2318 VDD!\#2318) pch w=4e-06 \
        l=1e-06 as=0 ad=1e-11 ps=0 pd=1.3e-05 sa=2e-06 sb=2e-06
    MX54_M0_unmatched (net402\#2 RNb\#6 VDD!\#2319 VDD!\#2319) pch w=4e-06 \
        l=1e-06 as=0 ad=1e-11 ps=0 pd=1.3e-05 sa=2e-06 sb=2e-06
    MX55_M0_unmatched (mout\#7 n20\#2311 net402 net402) pch w=4e-06 \
        l=1e-06 as=0 ad=1e-11 ps=0 pd=1.3e-05 sa=2e-06 sb=2e-06
    MX62_M0_unmatched (Q\#3 qbint\#2313 VDD!\#2315 VDD!\#2315) pch w=4e-06 \
        l=1e-06 as=0 ad=1e-11 ps=0 pd=1.3e-05 sa=2e-06 sb=2e-06
    MX61_M0_unmatched (n43 RNb\#2311 VDD!\#2316 VDD!\#2316) pch w=4e-06 \
        l=1e-06 as=0 ad=1e-11 ps=0 pd=1.3e-05 sa=2e-06 sb=2e-06
    MX60_M0_unmatched (n41 qbint\#2314 n43\#2 n43\#2) pch w=4e-06 l=1e-06 \
        as=0 ad=1e-11 ps=0 pd=1.3e-05 sa=2e-06 sb=2e-06
    MX59_M0_unmatched (n35\#8 CKbb\#5 n41\#2 n41\#2) pch w=4e-06 l=1e-06 \
        as=0 ad=1e-11 ps=0 pd=1.3e-05 sa=2e-06 sb=2e-06
    MX51_M0_unmatched (n22 D\#2 VDD!\#22 VDD!\#22) pch w=4e-06 l=1e-06 \
        as=0 ad=1e-11 ps=0 pd=1.3e-05 sa=2e-06 sb=2e-06
    MX50_M0_unmatched (n20\#3 CKbb\#9 n22\#2 n22\#2) pch w=4e-06 l=1e-06 \
        as=0 ad=1e-11 ps=0 pd=1.3e-05 sa=2e-06 sb=2e-06
    MX46_M0_unmatched (CKb\#4 CK\#4 VDD!\#2313 VDD!\#2313) pch w=4e-06 \
        l=1e-06 as=0 ad=1e-11 ps=0 pd=1.3e-05 sa=2e-06 sb=2e-06
    MX48_M0_unmatched (n31\#2 mout\#3 VDD!\#23 VDD!\#23) pch w=4e-06 \
        l=1e-06 as=0 ad=1e-11 ps=0 pd=1.3e-05 sa=2e-06 sb=2e-06
    MX49_M0_unmatched (n20\#8 CKb\#2313 n31 n31) pch w=4e-06 l=1e-06 as=0 \
        ad=1e-11 ps=0 pd=1.3e-05 sa=2e-06 sb=2e-06
    MX47_M0_unmatched (CKbb\#2 CKb\#2314 VDD!\#24 VDD!\#24) pch w=4e-06 \
        l=1e-06 as=0 ad=1e-11 ps=0 pd=1.3e-05 sa=2e-06 sb=2e-06
ends DFFSRX1
// End of subcircuit definition.

// Library name: KISTA_SOI_STDLIB
// Cell name: AOI21X1
// View name: analog_extracted
subckt AOI21X1 A0 Y B0 A1
    C2 (A0\#2 Y) capacitor c=857.2a
    C7 (A0\#2 VSS!) capacitor c=6.37688e-18
    C16 (A0\#2 4) capacitor c=1.49001e-15
    C22 (A0\#2 net19) capacitor c=247.754a
    C35 (4 Y) capacitor c=5.98803e-15
    C36 (Y\#1 4) capacitor c=56.7488a
    C42 (net19 Y) capacitor c=52.5258a
    C43 (Y\#1 net19) capacitor c=140.494a
    C66 (4 VSS!) capacitor c=4.91368e-15
    C1 (Y A0) capacitor c=142.714a
    C6 (VSS! A0) capacitor c=11.6358a
    C15 (4 A0) capacitor c=3.80431e-15
    C3 (Y\#4 A0) capacitor c=182.029a
    C27 (Y\#4 VSS!) capacitor c=87.6192a
    C37 (Y\#4 4) capacitor c=1.48327e-15
    C4 (Y\#4 A0\#4) capacitor c=156.192a
    C8 (A0\#4 VSS!) capacitor c=65.4153a
    C17 (A0\#4 4) capacitor c=782.769a
    C5 (A0\#3 Y) capacitor c=16.6163a
    C9 (A0\#3 VSS!) capacitor c=1.19556e-19
    C18 (A0\#3 4) capacitor c=224.262a
    C10 (A0\#2 VDD!) capacitor c=10.9299a
    C23 (A0\#2 X7_5) capacitor c=504.33a
    C29 (Y\#1 VDD!) capacitor c=13.9618a
    C47 (Y\#1 X7_5) capacitor c=646.972a
    C61 (VDD! VSS!) capacitor c=7.32018e-18
    C73 (4 VDD!) capacitor c=6.76683e-15
    C90 (X7_5 net19) capacitor c=109.29a
    C91 (net19\#4 X7_5) capacitor c=79.165a
    C44 (net19\#4 Y) capacitor c=58.0138a
    C72 (net19\#4 VSS!) capacitor c=11.7783a
    C75 (net19\#4 VDD!) capacitor c=234.304a
    C88 (net19\#4 4) capacitor c=1.57237e-15
    C45 (net19\#3 Y) capacitor c=51.8397a
    C89 (net19\#3 4) capacitor c=1.41651e-15
    C11 (A1 A0) capacitor c=4.03514e-18
    C13 (A0\#3 A1) capacitor c=2.50993e-19
    C30 (A1 Y) capacitor c=418.236a
    C62 (A1 VSS!) capacitor c=9.0072e-18
    C79 (4 A1) capacitor c=3.73767e-15
    C12 (A1\#5 A0) capacitor c=4.13602e-20
    C19 (net17 A0) capacitor c=50.6958a
    C14 (A0\#3 A1\#5) capacitor c=2.57267e-21
    C21 (A0\#3 net17) capacitor c=7.3974e-19
    C20 (A0\#4 net17) capacitor c=138.05a
    C40 (Y\#4 net17) capacitor c=79.1422a
    C34 (A1\#5 Y) capacitor c=3.48892e-18
    C69 (net17 VSS!) capacitor c=74.0211a
    C82 (A1\#5 4) capacitor c=32.8518a
    C86 (net17 4) capacitor c=228.442a
    C41 (net17\#2 Y) capacitor c=3.62116e-18
    C70 (net17\#2 VSS!) capacitor c=63.6502a
    C87 (net17\#2 4) capacitor c=228.694a
    C24 (B0 Y) capacitor c=293.557a
    C49 (VSS! B0) capacitor c=4.5743e-18
    C55 (4 B0) capacitor c=4.37052e-15
    C25 (Y\#3 B0) capacitor c=34.5358a
    C32 (Y\#3 A1) capacitor c=5.78523e-18
    C64 (VSS!\#1 A1) capacitor c=7.48118e-18
    C28 (Y\#3 VSS!\#1) capacitor c=168.727a
    C39 (Y\#3 4) capacitor c=1.5977e-15
    C67 (VSS!\#1 4) capacitor c=528.518a
    C71 (VSS!\#1 net17\#2) capacitor c=72.1635a
    C38 (Y\#5 4) capacitor c=56.1811a
    C46 (net19\#3 Y\#5) capacitor c=273.208a
    C26 (Y\#3 B0\#4) capacitor c=274.546a
    C57 (B0\#4 4) capacitor c=2.46027e-15
    C31 (Y\#5 A1\#4) capacitor c=577.632a
    C63 (A1\#4 VSS!) capacitor c=13.9104a
    C80 (A1\#4 4) capacitor c=857.837a
    C84 (net19\#4 A1\#4) capacitor c=353.084a
    C33 (Y\#3 A1\#6) capacitor c=11.3428a
    C51 (VSS!\#2 B0) capacitor c=2.29042e-18
    C52 (VSS!\#2 B0\#4) capacitor c=190.428a
    C58 (B0\#3 4) capacitor c=2.43142e-19
    C65 (VSS!\#1 A1\#6) capacitor c=242.912a
    C83 (net17\#2 A1\#6) capacitor c=138.973a
    C81 (A1\#6 4) capacitor c=1.42508e-15
    C68 (VSS!\#2 4) capacitor c=1.84609e-15
    C50 (B0\#2 VSS!) capacitor c=10.8435a
    C56 (B0\#2 4) capacitor c=293.574a
    C74 (VDD!\#1 4) capacitor c=720.267a
    C53 (VDD!\#1 B0) capacitor c=53.4874a
    C54 (VDD!\#1 B0\#2) capacitor c=289.384a
    C59 (net19\#3 B0\#2) capacitor c=276.012a
    C76 (net19\#3 VDD!\#1) capacitor c=209.56a
    C77 (X5_5 VDD!) capacitor c=28.66a
    C60 (B0\#2 X5_5) capacitor c=532.553a
    C78 (VDD!\#1 X5_5) capacitor c=603.838a
    C93 (net19\#3 X5_5) capacitor c=149.036a
    C48 (Y\#5 X6_5) capacitor c=226.143a
    C85 (A1\#4 X6_5) capacitor c=510.168a
    C92 (net19\#4 X6_5) capacitor c=329.742a
    MX7_M0_unmatched (Y\#1 A0\#2 net19 net19) pch w=8e-06 l=1e-06 as=0 \
        ad=2e-11 ps=0 pd=2.1e-05 sa=2e-06 sb=2e-06
    MX5_M0_unmatched (net19\#3 B0\#2 VDD!\#1 VDD!\#1) pch w=8e-06 l=1e-06 \
        as=0 ad=2e-11 ps=0 pd=2.1e-05 sa=2e-06 sb=2e-06
    MX6_M0_unmatched (Y\#5 A1\#4 net19\#4 net19\#4) pch w=8e-06 l=1e-06 \
        as=0 ad=2e-11 ps=0 pd=2.1e-05 sa=2e-06 sb=2e-06
    Rc3 (Y\#1 Y) resistor r=1.435
    Rs1 (4 VSS!) resistor r=50
    Rd6 (Y Y\#4) resistor r=2.815
    Rd9 (A0\#2 A0\#3) resistor r=1636.0317
    Rd8 (A0\#3 A0) resistor r=85.469
    Rc13 (A0\#3 A0\#4) resistor r=436.0318
    Rd3 (net19 net19\#4) resistor r=3.795
    Rc12 (net19 net19\#3) resistor r=4.8158
    Rd2 (net19\#4 net19\#3) resistor r=4.6089
    Rc9 (net17 net17\#2) resistor r=5.075
    Rd5 (A1\#5 A1) resistor r=5.0512
    Rc15 (VSS!\#1 VSS!) resistor r=2.6779
    Rc10 (Y Y\#3) resistor r=6.8878
    Rc4 (Y Y\#5) resistor r=1.7829
    Rd7 (Y\#5 Y\#3) resistor r=32.1847
    Rd4 (A1\#4 A1\#5) resistor r=957.2891
    Rc2 (A1\#5 A1\#6) resistor r=957.2891
    Rd1 (B0\#3 B0\#4) resistor r=1936.0317
    Rc16 (VSS! VSS!\#2) resistor r=5.2044
    Rc14 (B0\#3 B0) resistor r=85.469
    Rc11 (B0\#2 B0\#3) resistor r=436.0318
    Rc17 (VDD! VDD!\#1) resistor r=1.5694
    MX4_M0_unmatched (Y\#4 A0\#4 net17 net17) nch w=4e-06 l=1e-06 as=0 \
        ad=1e-11 ps=0 pd=1.3e-05 sa=2e-06 sb=2e-06
    MX8_M0_unmatched (Y\#3 B0\#4 VSS!\#2 VSS!\#2) nch w=2e-06 l=1e-06 as=0 \
        ad=5e-12 ps=0 pd=9e-06 sa=2e-06 sb=2e-06
    MX3_M0_unmatched (net17\#2 A1\#6 VSS!\#1 VSS!\#1) nch w=4e-06 l=1e-06 \
        as=0 ad=1e-11 ps=0 pd=1.3e-05 sa=2e-06 sb=2e-06
ends AOI21X1
// End of subcircuit definition.

// Library name: KISTA_SOI_STDLIB
// Cell name: NAND3X1
// View name: analog_extracted
subckt NAND3X1 Y A C B
    C7 (VDD!\#1 Y\#5) capacitor c=180.524a
    C19 (A\#2 VSS!) capacitor c=8.57638e-18
    C21 (VDD!\#1 A\#2) capacitor c=235.165a
    C23 (A\#2 4) capacitor c=2.1019e-15
    C37 (4 VSS!) capacitor c=5.03315e-15
    C54 (VDD!\#1 4) capacitor c=2.58973e-15
    C3 (Y\#1 A\#2) capacitor c=857.057a
    C12 (Y\#1 4) capacitor c=9.00427e-15
    C15 (Y\#5 X5_5) capacitor c=406.72a
    C28 (A\#2 X5_5) capacitor c=508.173a
    C57 (VDD!\#1 X5_5) capacitor c=181.705a
    C25 (A\#3 4) capacitor c=1.54339e-19
    C4 (Y\#4 VSS!) capacitor c=95.3279a
    C2 (Y\#4 A\#4) capacitor c=225.6a
    C20 (A\#4 VSS!) capacitor c=65.5823a
    C24 (A\#4 4) capacitor c=1.44466e-15
    C18 (VSS! A) capacitor c=13.8464a
    C22 (4 A) capacitor c=5.59114e-15
    C1 (A Y) capacitor c=468.291a
    C26 (net59 A) capacitor c=10.5891a
    C13 (Y\#4 net59) capacitor c=79.1422a
    C27 (A\#4 net59) capacitor c=138.05a
    C42 (net59 VSS!) capacitor c=70.1866a
    C71 (net59 4) capacitor c=290.908a
    C14 (Y\#1 net59\#2) capacitor c=1.4e-18
    C43 (net59\#2 VSS!) capacitor c=71.2822a
    C72 (net59\#2 4) capacitor c=228.999a
    C10 (Y\#1 B) capacitor c=17.6227a
    C34 (B VSS!) capacitor c=23.0662a
    C61 (4 B) capacitor c=5.97715e-15
    C11 (Y\#1 B\#2) capacitor c=736.587a
    C35 (B\#2 VSS!) capacitor c=10.7683a
    C62 (B\#2 4) capacitor c=1.46611e-15
    C29 (C VSS!) capacitor c=17.5155a
    C46 (4 C) capacitor c=5.8835e-15
    C5 (Y\#3 C) capacitor c=57.657a
    C6 (Y\#3 C\#2) capacitor c=228.123a
    C30 (C\#2 VSS!) capacitor c=2.09966e-18
    C47 (C\#2 4) capacitor c=932.1a
    C8 (VDD!\#4 Y\#6) capacitor c=203.689a
    C52 (VDD!\#4 B\#2) capacitor c=234.092a
    C55 (VDD!\#4 4) capacitor c=36.9004a
    C53 (4 VDD!) capacitor c=2.83222e-15
    C16 (Y\#6 X4_5) capacitor c=148.996a
    C58 (VDD!\#4 X4_5) capacitor c=148.996a
    C68 (B\#2 X4_5) capacitor c=531.824a
    C64 (B\#3 4) capacitor c=1.74844e-19
    C65 (net60 B) capacitor c=3.479e-18
    C36 (B\#4 VSS!) capacitor c=71.1986a
    C39 (net60 VSS!) capacitor c=71.6533a
    C63 (B\#4 4) capacitor c=2.14032e-15
    C66 (B\#4 net60) capacitor c=138.05a
    C67 (net59\#2 B\#4) capacitor c=138.973a
    C73 (net59\#2 net60) capacitor c=72.8905a
    C69 (net60 4) capacitor c=359.489a
    C40 (net60\#2 VSS!) capacitor c=63.7969a
    C70 (net60\#2 4) capacitor c=228.999a
    C9 (VDD!\#3 Y\#3) capacitor c=173.76a
    C33 (VDD!\#3 VSS!) capacitor c=16.9417a
    C31 (VSS!\#1 C) capacitor c=2.10997e-18
    C38 (VSS!\#1 4) capacitor c=1.98294e-15
    C41 (VSS!\#1 net60\#2) capacitor c=72.1635a
    C44 (VDD!\#3 C) capacitor c=8.343e-18
    C45 (VDD!\#3 C\#2) capacitor c=242.464a
    C49 (C\#3 4) capacitor c=1.58946e-19
    C56 (VDD!\#3 4) capacitor c=1.37846e-15
    C48 (C\#4 4) capacitor c=2.7652e-15
    C32 (VSS!\#1 C\#4) capacitor c=239.517a
    C50 (net60\#2 C\#4) capacitor c=138.973a
    C59 (X3_5 VDD!) capacitor c=28.66a
    C17 (Y\#3 X3_5) capacitor c=181.705a
    C51 (C\#2 X3_5) capacitor c=531.582a
    C60 (VDD!\#3 X3_5) capacitor c=406.72a
    MX5_M0_unmatched (Y\#5 A\#2 VDD!\#1 VDD!\#1) pch w=4e-06 l=1e-06 as=0 \
        ad=1e-11 ps=0 pd=1.3e-05 sa=2e-06 sb=2e-06
    MX4_M0_unmatched (Y\#6 B\#2 VDD!\#4 VDD!\#4) pch w=4e-06 l=1e-06 as=0 \
        ad=1e-11 ps=0 pd=1.3e-05 sa=2e-06 sb=2e-06
    MX3_M0_unmatched (Y\#3 C\#2 VDD!\#3 VDD!\#3) pch w=4e-06 l=1e-06 as=0 \
        ad=1e-11 ps=0 pd=1.3e-05 sa=2e-06 sb=2e-06
    Rs1 (4 VSS!) resistor r=50
    Rc1 (Y\#1 Y\#5) resistor r=2.6231
    Rd7 (A\#2 A\#3) resistor r=2236.0317
    Rc9 (A\#3 A\#4) resistor r=1036.0317
    Rd9 (A\#3 A) resistor r=85.4665
    Rc4 (Y Y\#4) resistor r=2.625
    Rd6 (Y Y\#1) resistor r=398.1m
    Rc5 (net59 net59\#2) resistor r=5.075
    Rc14 (Y\#1 Y\#3) resistor r=3.1697
    Rd5 (Y\#1 Y\#6) resistor r=2.9473
    Rc13 (Y\#6 Y\#3) resistor r=46.4759
    Rd3 (VDD!\#1 VDD!\#4) resistor r=81.7283
    Rc11 (VDD! VDD!\#1) resistor r=2.9994
    Rc8 (VDD! VDD!\#4) resistor r=2.789
    Rd2 (B\#2 B\#3) resistor r=1636.0317
    Rd4 (B\#3 B) resistor r=85.4665
    Rc7 (B\#3 B\#4) resistor r=1636.0317
    Rc3 (net60 net60\#2) resistor r=5.075
    Rc16 (VSS! VSS!\#1) resistor r=2.7344
    Rc10 (C\#3 C) resistor r=85.4665
    Rd8 (C\#3 C\#4) resistor r=2236.0317
    Rc6 (C\#2 C\#3) resistor r=1036.0317
    Rd1 (VDD! VDD!\#3) resistor r=2.7069
    MX8_M0_unmatched (Y\#4 A\#4 net59 net59) nch w=4e-06 l=1e-06 as=0 \
        ad=1e-11 ps=0 pd=1.3e-05 sa=2e-06 sb=2e-06
    MX7_M0_unmatched (net59\#2 B\#4 net60 net60) nch w=4e-06 l=1e-06 as=0 \
        ad=1e-11 ps=0 pd=1.3e-05 sa=2e-06 sb=2e-06
    MX6_M0_unmatched (net60\#2 C\#4 VSS!\#1 VSS!\#1) nch w=4e-06 l=1e-06 \
        as=0 ad=1e-11 ps=0 pd=1.3e-05 sa=2e-06 sb=2e-06
ends NAND3X1
// End of subcircuit definition.

// Library name: KISTA_SOI_STDLIB
// Cell name: NOR3X1
// View name: analog_extracted
subckt NOR3X1 A B C Y
    C3 (Y\#4 C\#2) capacitor c=372.194a
    C15 (Y\#4 net60) capacitor c=214.54a
    C20 (C\#2 VSS!) capacitor c=3.29873e-18
    C23 (C\#2 4) capacitor c=258.954a
    C27 (C\#2 net60) capacitor c=357.573a
    C56 (4 VSS!) capacitor c=2.78463e-15
    C2 (Y\#4 C) capacitor c=364.655a
    C19 (VSS! C) capacitor c=15.276a
    C22 (4 C) capacitor c=4.44111e-15
    C26 (net60 C) capacitor c=52.1191a
    C25 (C\#3 4) capacitor c=3.68858e-19
    C24 (C\#4 4) capacitor c=2.29314e-15
    C1 (C\#4 Y) capacitor c=779.045a
    C14 (4 Y) capacitor c=7.48094e-15
    C4 (Y\#4 VDD!) capacitor c=66.2687a
    C17 (Y\#4 X8_5) capacitor c=834.381a
    C18 (C\#2 VDD!) capacitor c=63.9776a
    C28 (C\#2 X8_5) capacitor c=526.341a
    C32 (4 VDD!) capacitor c=6.09126e-15
    C37 (net60 VDD!) capacitor c=149.785a
    C62 (X8_5 VSS!) capacitor c=5.732e-18
    C77 (X8_5 net60) capacitor c=178.672a
    C61 (net60\#2 VSS!) capacitor c=2.94747e-18
    C73 (net60\#2 4) capacitor c=100.044a
    C9 (Y\#3 VSS!) capacitor c=237.408a
    C5 (Y\#3 A) capacitor c=90.4369a
    C41 (VSS! A) capacitor c=16.4815a
    C46 (4 A) capacitor c=4.36069e-15
    C6 (Y\#3 A\#4) capacitor c=136.031a
    C48 (A\#4 4) capacitor c=1.13196e-15
    C7 (A\#3 Y\#3) capacitor c=5.61971e-18
    C45 (A\#3 VSS!) capacitor c=1.04732e-18
    C49 (A\#3 4) capacitor c=249.118a
    C43 (VSS!\#3 A) capacitor c=23.9434a
    C42 (A\#2 VSS!) capacitor c=3.66463e-18
    C44 (VSS!\#3 A\#4) capacitor c=189.046a
    C16 (Y\#2 net60\#2) capacitor c=2.85752e-18
    C47 (A\#2 4) capacitor c=1.67969e-15
    C59 (VSS!\#3 4) capacitor c=1.67976e-15
    C8 (VSS!\#1 Y\#5) capacitor c=126.646a
    C21 (VSS!\#1 C\#4) capacitor c=179.769a
    C57 (VSS!\#1 4) capacitor c=2.76743e-15
    C10 (Y\#2 VSS!\#4) capacitor c=80.1849a
    C58 (VSS!\#4 4) capacitor c=186.083a
    C11 (Y\#2 B) capacitor c=27.2725a
    C52 (B VSS!) capacitor c=15.7514a
    C63 (4 B) capacitor c=4.68969e-15
    C12 (Y\#2 B\#4) capacitor c=727.572a
    C54 (VSS!\#4 B\#4) capacitor c=183.665a
    C13 (Y\#2 B\#3) capacitor c=1.6964e-18
    C55 (B\#3 VSS!) capacitor c=9.79766e-19
    C65 (B\#4 4) capacitor c=1.68242e-15
    C66 (B\#3 4) capacitor c=291.707a
    C67 (net61 B) capacitor c=11.6185a
    C34 (net61 VDD!) capacitor c=72.9903a
    C60 (net61 VSS!) capacitor c=6.01843e-18
    C69 (B\#3 net61) capacitor c=7.22692e-19
    C31 (B\#2 VDD!) capacitor c=63.9776a
    C53 (B\#2 VSS!) capacitor c=11.8177a
    C30 (VDD!\#1 VSS!) capacitor c=15.53a
    C29 (VDD!\#1 A\#2) capacitor c=453.526a
    C33 (VDD!\#1 4) capacitor c=294.187a
    C64 (B\#2 4) capacitor c=939.673a
    C72 (net61 4) capacitor c=162.667a
    C68 (B\#2 net61) capacitor c=357.573a
    C70 (net60\#2 B\#2) capacitor c=358.496a
    C74 (net60\#2 net61) capacitor c=208.289a
    C71 (B\#2 X7_5) capacitor c=522.396a
    C78 (net60\#2 X7_5) capacitor c=178.672a
    C38 (X7_5 VDD!) capacitor c=28.66a
    C75 (X7_5 net61) capacitor c=178.672a
    C35 (net61\#2 VDD!) capacitor c=64.8416a
    C39 (X6_5 VDD!) capacitor c=34.392a
    C36 (VDD!\#1 net61\#2) capacitor c=207.561a
    C40 (VDD!\#1 X6_5) capacitor c=834.381a
    C50 (net61\#2 A\#2) capacitor c=358.496a
    C51 (A\#2 X6_5) capacitor c=502.932a
    C76 (net61\#2 X6_5) capacitor c=178.672a
    MX8_M0_unmatched (Y\#4 C\#2 net60 net60) pch w=1.2e-05 l=1e-06 as=0 \
        ad=3e-11 ps=0 pd=2.9e-05 sa=2e-06 sb=2e-06
    MX7_M0_unmatched (net60\#2 B\#2 net61 net61) pch w=1.2e-05 l=1e-06 \
        as=0 ad=3e-11 ps=0 pd=2.9e-05 sa=2e-06 sb=2e-06
    MX6_M0_unmatched (net61\#2 A\#2 VDD!\#1 VDD!\#1) pch w=1.2e-05 l=1e-06 \
        as=0 ad=3e-11 ps=0 pd=2.9e-05 sa=2e-06 sb=2e-06
    Rc14 (Y\#2 Y\#6) resistor r=5.0795
    Rs1 (4 VSS!) resistor r=50
    Rd9 (C\#3 C) resistor r=85.4715
    Rd7 (C\#2 C\#3) resistor r=436.0318
    Rc9 (C\#3 C\#4) resistor r=1936.0317
    Rc5 (Y Y\#4) resistor r=1.2633
    Rc4 (net60 net60\#2) resistor r=1.9725
    Rd8 (A\#3 A\#4) resistor r=736.0318
    Rc10 (A\#3 A) resistor r=85.464
    Rc6 (A\#2 A\#3) resistor r=1636.0317
    Rc13 (Y\#2 Y\#3) resistor r=5.276
    Rd1 (VSS! VSS!\#3) resistor r=5.2019
    Rc1 (Y Y\#2) resistor r=222.2m
    Rd6 (Y Y\#5) resistor r=6.3778
    Rd5 (Y\#5 Y\#2) resistor r=26.2936
    Rc11 (VSS! VSS!\#1) resistor r=5.4301
    Rd3 (VSS!\#1 VSS!\#4) resistor r=364.9153
    Rc8 (VSS! VSS!\#4) resistor r=5.2279
    Rc7 (B\#3 B\#4) resistor r=1336.0317
    Rd4 (B\#3 B) resistor r=85.469
    Rd2 (B\#2 B\#3) resistor r=1036.0317
    Rc16 (VDD! VDD!\#1) resistor r=1.0827
    Rc2 (net61 net61\#2) resistor r=1.9725
    MX4_M0_unmatched (Y\#6 B\#4 VSS!\#4 VSS!\#4) nch w=2e-06 l=1e-06 as=0 \
        ad=5e-12 ps=0 pd=9e-06 sa=2e-06 sb=2e-06
    MX3_M0_unmatched (Y\#3 A\#4 VSS!\#3 VSS!\#3) nch w=2e-06 l=1e-06 as=0 \
        ad=5e-12 ps=0 pd=9e-06 sa=2e-06 sb=2e-06
    MX5_M0_unmatched (Y\#5 C\#4 VSS!\#1 VSS!\#1) nch w=2e-06 l=1e-06 as=0 \
        ad=5e-12 ps=0 pd=9e-06 sa=2e-06 sb=2e-06
ends NOR3X1
// End of subcircuit definition.

// Library name: KISTA_SOI_STDLIB
// Cell name: OAI21X1
// View name: analog_extracted
subckt OAI21X1 B0 Y A0 A1
    C5 (B0\#4 VSS!) capacitor c=6.24104e-18
    C7 (VDD!\#1 B0\#4) capacitor c=344.382a
    C9 (B0\#4 4) capacitor c=1.43864e-15
    C18 (Y\#4 VDD!\#1) capacitor c=251.355a
    C50 (4 VSS!) capacitor c=1.26675e-15
    C58 (VDD!\#1 4) capacitor c=2.69303e-15
    C2 (B0\#4 Y) capacitor c=863.743a
    C16 (VSS! Y) capacitor c=17.7406a
    C23 (4 Y) capacitor c=4.68705e-15
    C1 (Y B0) capacitor c=409.45a
    C4 (VSS! B0) capacitor c=12.5563a
    C8 (4 B0) capacitor c=4.91506e-15
    C10 (B0\#6 4) capacitor c=1.44686e-15
    C3 (Y\#3 B0\#6) capacitor c=223.289a
    C24 (Y\#3 4) capacitor c=535.387a
    C6 (VSS!\#1 B0\#6) capacitor c=65.1585a
    C17 (VSS!\#1 Y\#3) capacitor c=68.1642a
    C52 (VSS!\#1 4) capacitor c=5.44375e-15
    C11 (B0\#5 4) capacitor c=5.57378e-19
    C15 (B0\#4 X8_5) capacitor c=508.67a
    C28 (X8_5 Y) capacitor c=332.712a
    C63 (VDD!\#1 X8_5) capacitor c=648.336a
    C19 (Y\#2 VDD!) capacitor c=63.6186a
    C57 (4 VDD!) capacitor c=2.55705e-15
    C12 (net13\#4 B0) capacitor c=6.79721e-18
    C14 (net13\#2 B0) capacitor c=5.50113e-18
    C13 (net13\#4 B0\#6) capacitor c=146.232a
    C25 (net13\#4 Y\#3) capacitor c=79.1422a
    C26 (net13\#2 Y) capacitor c=17.1811a
    C79 (net13\#4 4) capacitor c=291.16a
    C80 (net13\#2 4) capacitor c=1.74972e-15
    C54 (VSS!\#1 net13) capacitor c=278.956a
    C78 (net13 4) capacitor c=2.23486e-15
    C20 (A1 Y) capacitor c=9.80229e-18
    C46 (A1 VSS!) capacitor c=18.9117a
    C67 (4 A1) capacitor c=4.95189e-15
    C71 (net13\#2 A1) capacitor c=11.6618a
    C21 (Y\#2 A1\#2) capacitor c=257.023a
    C47 (A1\#2 VSS!) capacitor c=7.24756e-18
    C56 (A1\#2 VDD!) capacitor c=63.9776a
    C68 (A1\#2 4) capacitor c=974.49a
    C22 (A1\#3 Y) capacitor c=6.09111e-19
    C29 (X7_5 Y) capacitor c=79.727a
    C30 (Y\#2 X7_5) capacitor c=88.0485a
    C49 (A1\#3 VSS!) capacitor c=1.17516e-18
    C64 (X7_5 VDD!) capacitor c=28.66a
    C70 (A1\#3 4) capacitor c=307.708a
    C73 (A1\#3 net13\#2) capacitor c=7.24662e-19
    C77 (A1\#2 X7_5) capacitor c=522.291a
    C83 (X7_5 net15) capacitor c=178.573a
    C27 (Y\#2 net15) capacitor c=140.59a
    C60 (net15 VDD!) capacitor c=72.0445a
    C74 (net15 A1) capacitor c=11.0458a
    C75 (A1\#2 net15) capacitor c=247.812a
    C76 (A1\#3 net15) capacitor c=6.86382e-19
    C69 (A1\#4 4) capacitor c=1.95581e-15
    C72 (net13\#2 A1\#4) capacitor c=792.435a
    C81 (net15 4) capacitor c=112.243a
    C55 (net15\#2 VSS!) capacitor c=5.05691e-18
    C61 (net15\#2 VDD!) capacitor c=64.1265a
    C82 (net15\#2 4) capacitor c=50.1172a
    C31 (VSS! A0) capacitor c=17.4085a
    C38 (4 A0) capacitor c=4.76614e-15
    C32 (A0\#2 VSS!) capacitor c=2.33242e-18
    C39 (A0\#2 4) capacitor c=260.449a
    C43 (net15\#2 A0\#2) capacitor c=248.735a
    C33 (VSS!\#1 A0\#4) capacitor c=226.587a
    C40 (A0\#4 4) capacitor c=2.62846e-15
    C42 (A0\#4 net13) capacitor c=779.727a
    C34 (A0\#3 VSS!) capacitor c=6.18207e-19
    C41 (A0\#3 4) capacitor c=273.703a
    C48 (VSS!\#3 A1\#4) capacitor c=211.778a
    C53 (VSS!\#3 net13\#2) capacitor c=206.715a
    C51 (VSS!\#3 4) capacitor c=225.171a
    C45 (VDD!\#2 VSS!) capacitor c=6.38307e-18
    C59 (VDD!\#2 4) capacitor c=1.27811e-15
    C35 (VDD!\#2 A0) capacitor c=57.7159a
    C36 (VDD!\#2 A0\#2) capacitor c=345.49a
    C37 (A0\#3 VDD!\#2) capacitor c=7.41669e-19
    C62 (VDD!\#2 net15\#2) capacitor c=139.862a
    C65 (X6_5 VDD!) capacitor c=28.66a
    C44 (A0\#2 X6_5) capacitor c=503.676a
    C66 (VDD!\#2 X6_5) capacitor c=648.336a
    C84 (net15\#2 X6_5) capacitor c=178.63a
    MX8_M0_unmatched (Y\#4 B0\#4 VDD!\#1 VDD!\#1) pch w=8e-06 l=1e-06 as=0 \
        ad=2e-11 ps=0 pd=2.1e-05 sa=2e-06 sb=2e-06
    MX7_M0_unmatched (Y\#2 A1\#2 net15 net15) pch w=8e-06 l=1e-06 as=0 \
        ad=2e-11 ps=0 pd=2.1e-05 sa=2e-06 sb=2e-06
    MX6_M0_unmatched (net15\#2 A0\#2 VDD!\#2 VDD!\#2) pch w=8e-06 l=1e-06 \
        as=0 ad=2e-11 ps=0 pd=2.1e-05 sa=2e-06 sb=2e-06
    Rs1 (4 VSS!) resistor r=50
    Rd8 (Y Y\#4) resistor r=2.2262
    Rc6 (Y\#4 Y\#2) resistor r=6.6694
    Rd1 (Y Y\#2) resistor r=2.3261
    Rc5 (Y Y\#3) resistor r=2.6175
    Rc8 (VSS! VSS!\#1) resistor r=2.972
    Rd7 (B0\#4 B0\#5) resistor r=1636.0317
    Rc14 (VDD!\#1 VDD!) resistor r=1.8054
    Rd9 (B0\#5 B0) resistor r=85.474
    Rc4 (B0\#5 B0\#6) resistor r=1036.0317
    Rc11 (net13\#4 net13\#2) resistor r=7.2395
    Rd6 (net13\#4 net13) resistor r=8.7045
    Rc1 (net13\#2 net13) resistor r=8.4101
    Rd4 (A1\#3 A1) resistor r=85.464
    Rd2 (A1\#2 A1\#3) resistor r=1036.0317
    Rc13 (A1\#3 A1\#4) resistor r=1636.0317
    Rc2 (net15 net15\#2) resistor r=2.7059
    Rd3 (A0\#3 A0\#4) resistor r=2236.0317
    Rc3 (VSS!\#3 VSS!\#1) resistor r=31.9527
    Rd5 (VSS! VSS!\#3) resistor r=3.0612
    Rc10 (A0\#3 A0) resistor r=85.474
    Rc12 (A0\#2 A0\#3) resistor r=436.0318
    Rc15 (VDD! VDD!\#2) resistor r=1.5019
    MX5_M0_unmatched (Y\#3 B0\#6 net13\#4 net13\#4) nch w=4e-06 l=1e-06 \
        as=0 ad=1e-11 ps=0 pd=1.3e-05 sa=2e-06 sb=2e-06
    MX3_M0_unmatched (net13 A0\#4 VSS!\#1 VSS!\#1) nch w=4e-06 l=1e-06 \
        as=0 ad=1e-11 ps=0 pd=1.3e-05 sa=2e-06 sb=2e-06
    MX4_M0_unmatched (net13\#2 A1\#4 VSS!\#3 VSS!\#3) nch w=4e-06 l=1e-06 \
        as=0 ad=1e-11 ps=0 pd=1.3e-05 sa=2e-06 sb=2e-06
ends OAI21X1
// End of subcircuit definition.

// Library name: KISTA_SOI_STDLIB
// Cell name: XOR2X1
// View name: analog_extracted
subckt XOR2X1 Y A B
    C52 (B\#4 VSS!) capacitor c=1.54754e-18
    C63 (4 VSS!) capacitor c=6.14009e-15
    C68 (VDD!\#1 B\#4) capacitor c=185.383a
    C72 (VDD!\#1 4) capacitor c=4.78117e-15
    C74 (VDD!\#1 bb) capacitor c=104.577a
    C85 (B\#4 4) capacitor c=1.70972e-15
    C90 (B\#4 bb) capacitor c=152.135a
    C4 (Y\#5 VSS!) capacitor c=19.9182a
    C6 (Y\#5 B\#2) capacitor c=111.672a
    C54 (B\#2 VSS!) capacitor c=3.85945e-18
    C87 (B\#2 4) capacitor c=520.949a
    C11 (Y\#5 ab) capacitor c=118.307a
    C57 (ab VSS!) capacitor c=9.80419e-18
    C79 (B\#2 ab) capacitor c=114.863a
    C95 (4 ab) capacitor c=807.966a
    C12 (Y\#5 ab\#2) capacitor c=76.8931a
    C60 (ab\#2 VSS!) capacitor c=172.313a
    C80 (B\#2 ab\#2) capacitor c=60.2108a
    C98 (ab\#2 4) capacitor c=2.79194e-15
    C13 (Y\#4 4) capacitor c=3.80281e-15
    C3 (A\#3 Y\#4) capacitor c=616.533a
    C24 (A\#3 VSS!) capacitor c=2.74126e-18
    C44 (A\#3 4) capacitor c=3.37225e-15
    C8 (Y\#4 B) capacitor c=756.14a
    C51 (B VSS!) capacitor c=16.7171a
    C84 (4 B) capacitor c=5.14914e-15
    C56 (B\#5 VSS!) capacitor c=2.4922e-18
    C89 (B\#5 4) capacitor c=5.35144e-15
    C93 (B\#4 X7_5) capacitor c=525.087a
    C75 (VDD!\#1 X7_5) capacitor c=443.612a
    C105 (X7_5 bb) capacitor c=166.331a
    C71 (4 VDD!) capacitor c=6.00194e-15
    C5 (Y\#2 VDD!) capacitor c=33.3807a
    C1 (Y\#1 A\#2) capacitor c=94.3841a
    C21 (A\#2 VSS!) capacitor c=6.2576e-18
    C28 (A\#2 VDD!) capacitor c=10.3612a
    C42 (A\#2 4) capacitor c=2.59682e-15
    C2 (Y\#2 A\#6) capacitor c=163.317a
    C19 (A\#6 VSS!) capacitor c=8.26377e-18
    C27 (A\#6 VDD!) capacitor c=10.2055a
    C40 (A\#6 4) capacitor c=369.079a
    C7 (Y\#2 B\#3) capacitor c=154.007a
    C31 (B\#3 A\#6) capacitor c=160.607a
    C32 (A\#3 B\#3) capacitor c=556.191a
    C25 (A\#4 VSS!) capacitor c=1.59423e-18
    C45 (A\#4 4) capacitor c=2.07807e-15
    C55 (B\#3 VSS!) capacitor c=6.20291e-18
    C69 (B\#3 VDD!) capacitor c=17.6593a
    C88 (B\#3 4) capacitor c=526.328a
    C82 (ab\#4 B) capacitor c=171.022a
    C100 (ab\#4 4) capacitor c=2.86517e-15
    C17 (Y\#2 X5_5) capacitor c=325.53a
    C48 (A\#6 X5_5) capacitor c=510.865a
    C76 (X5_5 VDD!) capacitor c=44.9148a
    C94 (B\#3 X5_5) capacitor c=163.225a
    C81 (ab\#6 B\#3) capacitor c=151.818a
    C37 (A\#4 ab\#6) capacitor c=597.003a
    C61 (ab\#6 VSS!) capacitor c=4.14725e-18
    C99 (ab\#6 4) capacitor c=1.22865e-15
    C10 (Y\#7 ab\#3) capacitor c=70.7458a
    C59 (ab\#3 VSS!) capacitor c=133.42a
    C97 (ab\#3 4) capacitor c=2.35621e-15
    C9 (Y\#7 ab\#7) capacitor c=136.839a
    C58 (ab\#7 VSS!) capacitor c=7.30139e-18
    C83 (B\#5 ab\#7) capacitor c=13.4904a
    C96 (ab\#7 4) capacitor c=269.441a
    C14 (Y\#7 bb\#4) capacitor c=104.008a
    C67 (bb\#4 VSS!) capacitor c=28.1563a
    C92 (B\#5 bb\#4) capacitor c=638.19a
    C86 (B\#6 4) capacitor c=1.18894e-15
    C101 (bb\#4 ab\#7) capacitor c=174.523a
    C16 (Y\#7 X6_5) capacitor c=165.414a
    C102 (ab\#7 X6_5) capacitor c=527.014a
    C106 (bb\#4 X6_5) capacitor c=361.084a
    C15 (Y\#1 bb\#2) capacitor c=77.4311a
    C47 (bb\#2 A\#2) capacitor c=276.05a
    C104 (bb\#2 4) capacitor c=3.91701e-15
    C91 (bb\#6 B\#6) capacitor c=89.5926a
    C18 (VSS! A) capacitor c=11.6707a
    C33 (ab\#6 A) capacitor c=148.606a
    C35 (ab\#4 A) capacitor c=126.361a
    C39 (4 A) capacitor c=3.71093e-15
    C20 (A\#7 VSS!) capacitor c=5.24098e-18
    C34 (ab\#6 A\#7) capacitor c=163.729a
    C41 (A\#7 4) capacitor c=374.574a
    C26 (A\#5 VSS!) capacitor c=7.2521e-19
    C38 (A\#5 ab\#4) capacitor c=14.5676a
    C46 (A\#5 4) capacitor c=212.514a
    C36 (ab\#4 A\#8) capacitor c=239.053a
    C43 (A\#8 4) capacitor c=1.80265e-15
    C22 (VSS!\#2 A) capacitor c=4.9696e-18
    C29 (VDD!\#2 A) capacitor c=8.46894e-18
    C23 (VSS!\#2 A\#8) capacitor c=132.678a
    C62 (VSS!\#2 ab\#4) capacitor c=190.102a
    C30 (VDD!\#2 A\#7) capacitor c=185.383a
    C50 (VDD!\#2 VSS!) capacitor c=12.7774a
    C65 (VSS!\#2 4) capacitor c=5.24353e-15
    C53 (VSS!\#1 B\#6) capacitor c=133.008a
    C66 (bb\#6 VSS!\#1) capacitor c=60.2848a
    C64 (VSS!\#1 4) capacitor c=1.16182e-15
    C73 (VDD!\#2 4) capacitor c=1.17583e-15
    C70 (VDD!\#2 ab\#6) capacitor c=102.283a
    C77 (X4_5 VDD!) capacitor c=22.4574a
    C49 (A\#7 X4_5) capacitor c=507.908a
    C78 (VDD!\#2 X4_5) capacitor c=437.88a
    C103 (ab\#6 X4_5) capacitor c=176.129a
    MX7_M0_unmatched (bb B\#4 VDD!\#1 VDD!\#1) pch w=4e-06 l=1e-06 as=0 \
        ad=1e-11 ps=0 pd=1.3e-05 sa=2e-06 sb=2e-06
    MX5_M0_unmatched (Y\#2 A\#6 B\#3 B\#3) pch w=4e-06 l=1e-06 as=0 \
        ad=1e-11 ps=0 pd=1.3e-05 sa=2e-06 sb=2e-06
    MX6_M0_unmatched (Y\#7 ab\#7 bb\#4 bb\#4) pch w=4e-06 l=1e-06 as=0 \
        ad=1e-11 ps=0 pd=1.3e-05 sa=2e-06 sb=2e-06
    MX4_M0_unmatched (ab\#6 A\#7 VDD!\#2 VDD!\#2) pch w=4e-06 l=1e-06 as=0 \
        ad=1e-11 ps=0 pd=1.3e-05 sa=2e-06 sb=2e-06
    Rs1 (4 VSS!) resistor r=50
    Rc7 (ab ab\#2) resistor r=362.2892
    Rd1 (Y\#4 Y) resistor r=22.05m
    Rc13 (Y\#4 Y\#5) resistor r=5.7275
    Rc14 (Y\#7 Y\#5) resistor r=59.7367
    Rc12 (Y\#4 Y\#7) resistor r=2.964
    Rc8 (B B\#2) resistor r=5.165
    Rd5 (B\#5 B\#2) resistor r=5270217
    Rc9 (B\#4 B\#5) resistor r=1569.2584
    Rc21 (VDD!\#1 VDD!) resistor r=3.2804
    Rc6 (B\#5 B) resistor r=2552.1631
    Rd9 (Y\#2 Y\#4) resistor r=2.8324
    Rc4 (Y\#1 Y\#4) resistor r=5.7782
    Rc3 (Y\#1 Y\#2) resistor r=64.7528
    Rc1 (A\#3 A\#2) resistor r=1878.0677
    Rd6 (A\#3 A\#6) resistor r=388.6361
    Rd2 (A\#3 A\#4) resistor r=1132.8945
    Rd4 (B B\#3) resistor r=2.81
    Rd11 (ab\#2 ab\#4) resistor r=5.611
    Rd12 (ab\#2 ab\#6) resistor r=3.3386
    Rd10 (ab\#3 ab\#2) resistor r=5.2
    Rc11 (ab\#7 ab\#3) resistor r=357.2892
    Rc2 (ab\#6 ab\#4) resistor r=73.2344
    Rd8 (B\#5 B\#6) resistor r=819.2584
    Rc20 (bb\#5 bb\#4) resistor r=2.5
    Rc16 (bb bb\#5) resistor r=3.3083
    Rc15 (bb bb\#2) resistor r=34.8243
    Rc19 (bb\#2 bb\#5) resistor r=6.3929
    Rc18 (bb\#5 bb\#6) resistor r=5.1
    Rc5 (A\#4 A\#7) resistor r=444.2584
    Rd7 (A\#4 A\#5) resistor r=580.2902
    Rd3 (A\#5 A) resistor r=85.464
    Rc10 (A\#5 A\#8) resistor r=1336.0317
    Rc24 (VSS! VSS!\#2) resistor r=5.8052
    Rc23 (VSS!\#1 VSS!) resistor r=5.2579
    Rc22 (VDD! VDD!\#2) resistor r=2.8327
    MX9_M0_unmatched (Y\#5 ab B\#2 B\#2) nch w=2e-06 l=1e-06 as=0 ad=5e-12 \
        ps=0 pd=9e-06 sa=2e-06 sb=2e-06
    MX10_M0_unmatched (Y\#1 A\#2 bb\#2 bb\#2) nch w=2e-06 l=1e-06 as=0 \
        ad=5e-12 ps=0 pd=9e-06 sa=2e-06 sb=2e-06
    MX8_M0_unmatched (ab\#4 A\#8 VSS!\#2 VSS!\#2) nch w=2e-06 l=1e-06 as=0 \
        ad=5e-12 ps=0 pd=9e-06 sa=2e-06 sb=2e-06
    MX11_M0_unmatched (bb\#6 B\#6 VSS!\#1 VSS!\#1) nch w=2e-06 l=1e-06 \
        as=0 ad=5e-12 ps=0 pd=9e-06 sa=2e-06 sb=2e-06
ends XOR2X1
// End of subcircuit definition.

// Library name: KISTA_SOI_STDLIB
// Cell name: timing
// View name: schematic
I0 (net1 net2) INVX1_analog_extracted
I1 (net4 net3 net5) NOR2X1_analog_extracted
I2 (net7 net6) BUFX2_analog_extracted
I3 (net9 net8 net10) NAND2X1_analog_extracted
I5 (net11 net14 net12 net13) DFFX1_analog_extracted
I6 (net15) TIEHI_analog_extracted
I7 (net16) TIELO_analog_extracted
I8 (net017 net020 net019 net018) MX2X1
I9 (net022 net025 net026 net023 net021 net024) DFFSRX1
I10 (net028 net027 net030 net029) AOI21X1
I11 (net031 net032 net034 net033) NAND3X1
I12 (net036 net037 net038 net035) NOR3X1
I13 (net042 net039 net040 net041) OAI21X1
I14 (net043 net044 net045) XOR2X1
simulatorOptions options psfversion="1.1.0" reltol=1e-3 vabstol=1e-6 \
    iabstol=1e-12 temp=27 tnom=27 scalem=1.0 scale=1.0 gmin=1e-12 rforce=1 \
    maxnotes=5 maxwarns=5 digits=5 cols=80 pivrel=1e-3 \
    sensfile="../psf/sens.output" checklimitdest=psf
modelParameter info what=models where=rawfile
element info what=inst where=rawfile
outputParameter info what=output where=rawfile
designParamVals info what=parameters where=rawfile
primitives info what=primitives where=rawfile
subckts info what=subckts where=rawfile
saveOptions options save=allpub
