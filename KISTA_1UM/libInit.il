printf("KISTA libInit.il file is loaded\n")

printf("initializing MOS callbacks\n");
load("./KISTA_1UM/skill/kallhall_mos_l.cb");
load("./KISTA_1UM/skill/kallhall_mos_w.cb");
