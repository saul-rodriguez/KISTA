ADE simulation setup
Test KISTA_TEST_ANALOG_test_res_1: KISTA_TEST_ANALOG/test_res/schematic, simulator spectre
  Models: /home/saul/projects/KISTA/models/spectre/kth/KTH_RES.scs[restm]
  Temperature: 27
  Analysis dc: (saves the operating point)
  Signals: /R0/PLUS (terminal)
Run mode: Single Run, Sweeps and Corners
