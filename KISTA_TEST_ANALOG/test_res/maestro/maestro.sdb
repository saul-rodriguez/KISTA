ADE simulation setup
Run mode: Single Run, Sweeps and Corners
Tests:
  KISTA_TEST_ANALOG_test_res_1: KISTA_TEST_ANALOG/test_res/schematic, simulator spectre
    Outputs: /R0/PLUS
