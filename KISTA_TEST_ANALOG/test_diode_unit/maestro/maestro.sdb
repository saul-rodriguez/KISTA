ADE simulation setup
Run mode: Single Run, Sweeps and Corners
Tests:
  KISTA_TEST_ANALOG_test_diode_unit_1: KISTA_TEST_ANALOG/test_diode_unit/schematic, simulator spectre
