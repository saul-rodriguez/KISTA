ADE simulation setup
Test KISTA_TEST_ANALOG_test_diode_unit_1: KISTA_TEST_ANALOG/test_diode_unit/schematic, simulator spectre
  Models: /home/saul/projects/KISTA/models/spectre/kth/KTH_DIODE.scs[tt_dio]
  Temperature: 27
  Analysis dc: (saves the operating point)
Run mode: Single Run, Sweeps and Corners
