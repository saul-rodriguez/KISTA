ADE simulation setup
Run mode: Single Run, Sweeps and Corners
Tests:
  KISTA_TEST_ANALOG:test_pmos_dc:1 (off): KISTA_TEST_ANALOG/test_pmos_dc/schematic, simulator spectre
    Outputs: abs(IS("/M1/D"))
  KISTA_TEST_ANALOG:test_pmos_dc:1:1: KISTA_TEST_ANALOG/test_pmos_dc/schematic, simulator spectre
    Outputs: abs(IS("/M1/D"))
Global variables:
  VDS1 = 0:0.1:1.8
  VGS1 = 0.5
