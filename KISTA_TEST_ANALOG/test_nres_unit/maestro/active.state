ADE simulation setup
Test KISTA_TEST_ANALOG_test_nres_unit_1: KISTA_TEST_ANALOG/test_nres_unit/schematic, simulator spectre
  Models: /home/saul/projects/KISTA/models/spectre/kth/KTH_RES.scs[restm]
  Temperature: 150.0
  Analysis dc: (saves the operating point)
  Signals: /R0/PLUS (terminal)
Run mode: Single Run, Sweeps and Corners
