ADE simulation setup
Run mode: Single Run, Sweeps and Corners
Tests:
  KISTA_TEST_ANALOG:test_nmos_dc:1 (off): KISTA_TEST_ANALOG/test_nmos_dc/schematic, simulator spectre
  KISTA_TEST_ANALOG:test_nmos_dc:1:1: KISTA_TEST_ANALOG/test_nmos_dc/schematic, simulator spectre
Global variables:
  VDS1 = 0:0.05:1.8
  VGS1 = 0.5
