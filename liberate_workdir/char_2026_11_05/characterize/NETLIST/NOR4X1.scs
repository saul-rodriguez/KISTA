// NOR4X1
simulator lang=spectre insensitive=yes
global vss vdd
subckt NOR4X1 C D Y A B
    Rs1  (5 vss)  resistor r=50
    Rc23  (vdd vdd\#1)  resistor r=2.8572
    Rc2  (net1 net1\#2)  resistor r=5.05
    Rd10  (A\#2 A\#3)  resistor r=2536.0317
    Rc5  (net2 net2\#2)  resistor r=5.05
    Rc7  (net3 net3\#2)  resistor r=5.05
    Rd7  (C\#2 C\#3)  resistor r=1936.0317
    Rd9  (C\#3 C)  resistor r=85.564
    Rc8  (D\#2 D\#3)  resistor r=1336.0317
    Rd1  (Y Y\#5)  resistor r=2.875
    Rc13  (D\#3 D)  resistor r=85.564
    Rc11  (Y Y\#1)  resistor r=198.1m
    Rd8  (D\#3 D\#4)  resistor r=2236.0317
    Rc12  (C\#3 C\#4)  resistor r=1636.0317
    Rc17  (vss\#2 vss\#6)  resistor r=5.0974
    Rc10  (Y\#1 Y\#7)  resistor r=9.8566
    Rc16  (Y\#7 Y\#3)  resistor r=10.8855
    Rd2  (Y\#1 Y\#3)  resistor r=380.7m
    Rc21  (vss vss\#2)  resistor r=99.44m
    Rc9  (B\#2 B\#4)  resistor r=1936.0317
    Rc15  (B\#2 B)  resistor r=85.564
    Rd11  (B\#2 B\#3)  resistor r=1636.0317
    Rd12  (A\#3 A)  resistor r=85.564
    Rc14  (A\#3 A\#4)  resistor r=1036.0317
    Rc20  (Y\#3 Y\#4)  resistor r=5.276
    Rc19  (vss\#2 vss\#4)  resistor r=5.2981
    Rc18  (vss\#7 vss\#4)  resistor r=409.146
    Rd6  (Y\#3 Y\#8)  resistor r=5.0795
    Rc22  (vss\#2 vss\#7)  resistor r=5.2285
    Rd4  (vss\#5 vss\#2)  resistor r=15.3582
    Rd3  (Y\#1 Y\#6)  resistor r=5.0981
    Rd5  (vss vss\#5)  resistor r=7.6791
    C43  (Y\#5 D\#2)  capacitor c=260.27a
    C47  (D\#2 vss)  capacitor c=1.95867e-18
    C51  (D\#2 5)  capacitor c=1.25566e-15
    C55  (D\#2 net3)  capacitor c=139.36a
    C70  (Y\#5 net3)  capacitor c=82.8682a
    C108  (net3 5)  capacitor c=78.2413a
    C2  (D\#2 vdd)  capacitor c=66.3a
    C3  (Y\#5 vdd)  capacitor c=71.0989a
    C5  (vss vdd)  capacitor c=10.2965a
    C7  (5 vdd)  capacitor c=9.63892e-15
    C14  (net3 vdd)  capacitor c=76.8452a
    C1  (C\#2 vdd)  capacitor c=66.3a
    C23  (Y\#5 C\#2)  capacitor c=4.75482e-18
    C27  (C\#2 vss)  capacitor c=9.12449e-18
    C35  (C\#2 5)  capacitor c=2.03842e-15
    C8  (vdd\#1 5)  capacitor c=9.42396e-15
    C4  (vdd\#1 A\#2)  capacitor c=239.843a
    C73  (A\#2 vss)  capacitor c=2.39228e-18
    C80  (A\#2 5)  capacitor c=2.74569e-15
    C6  (vdd\#1 B\#4)  capacitor c=66.1897a
    C86  (B\#4 vss)  capacitor c=2.61014e-18
    C95  (B\#4 5)  capacitor c=2.04089e-15
    C9  (vdd\#1 net1)  capacitor c=76.8452a
    C90  (net1 vss)  capacitor c=3.43305e-18
    C99  (B\#4 net1)  capacitor c=139.36a
    C104  (net1 5)  capacitor c=79.0526a
    C10  (vdd\#1 net1\#2)  capacitor c=144.594a
    C83  (net1\#2 A\#2)  capacitor c=139.36a
    C105  (net1\#2 5)  capacitor c=79.4518a
    C112  (net1\#2 X4_5)  capacitor c=319.404a
    C17  (vdd\#1 X4_5)  capacitor c=474.675a
    C84  (A\#2 X4_5)  capacitor c=502.969a
    C13  (vdd\#1 net2\#2)  capacitor c=65.8752a
    C12  (net2\#2 vdd)  capacitor c=10.97a
    C76  (A\#3 vss)  capacitor c=6.19093e-19
    C82  (A\#3 5)  capacitor c=382.174a
    C101  (net2\#2 B\#4)  capacitor c=139.36a
    C107  (net2\#2 5)  capacitor c=211.296a
    C110  (net2\#2 net1)  capacitor c=79.6223a
    C11  (net2 vdd)  capacitor c=76.8452a
    C39  (C\#2 net2)  capacitor c=139.36a
    C91  (net2 vss)  capacitor c=6.15782e-18
    C106  (net2 5)  capacitor c=78.5913a
    C15  (net3\#2 vdd)  capacitor c=76.8672a
    C16  (X6_5 vdd)  capacitor c=30.6619a
    C40  (net3\#2 C\#2)  capacitor c=139.36a
    C41  (C\#2 X6_5)  capacitor c=521.869a
    C92  (net3\#2 vss)  capacitor c=2.20455e-18
    C109  (net3\#2 5)  capacitor c=79.4518a
    C113  (net3\#2 net2)  capacitor c=79.6223a
    C114  (X6_5 net2)  capacitor c=319.404a
    C117  (net3\#2 X6_5)  capacitor c=319.404a
    C38  (net2 C)  capacitor c=3.17032e-18
    C71  (Y\#1 net3\#2)  capacitor c=1.22851e-18
    C26  (vss C)  capacitor c=14.2112a
    C29  (C\#3 vss)  capacitor c=3.02005e-19
    C34  (5 C)  capacitor c=6.61918e-15
    C37  (C\#3 5)  capacitor c=371.059a
    C69  (Y\#1 5)  capacitor c=11.2603f
    C18  (D C)  capacitor c=21.7969a
    C19  (C\#3 D)  capacitor c=6.38834e-19
    C46  (vss D)  capacitor c=12.1064a
    C50  (5 D)  capacitor c=6.35251e-15
    C54  (net3 D)  capacitor c=23.0498a
    C116  (X7_5 net3)  capacitor c=319.404a
    C56  (D\#2 X7_5)  capacitor c=526.378a
    C20  (D\#3 C)  capacitor c=1.38154e-18
    C21  (D\#3 C\#3)  capacitor c=4.04908e-20
    C49  (D\#3 vss)  capacitor c=1.86083e-19
    C53  (D\#3 5)  capacitor c=355.816a
    C72  (Y\#5 X7_5)  capacitor c=437.88a
    C93  (X7_5 vss)  capacitor c=6.13238e-18
    C22  (Y C)  capacitor c=21.9089a
    C24  (C\#3 Y)  capacitor c=1.38864e-18
    C42  (Y D)  capacitor c=531.741a
    C44  (D\#3 Y)  capacitor c=30.4853a
    C45  (Y\#1 D\#4)  capacitor c=797.342a
    C52  (D\#4 5)  capacitor c=2.60501e-15
    C25  (Y\#1 C\#4)  capacitor c=711.011a
    C36  (C\#4 5)  capacitor c=1.99981e-15
    C28  (vss\#6 C\#4)  capacitor c=190.233a
    C61  (vss\#6 Y\#7)  capacitor c=164.746a
    C89  (vss\#2 5)  capacitor c=20.2132f
    C30  (B C)  capacitor c=58.3087a
    C31  (B\#2 C)  capacitor c=25.8323a
    C32  (C\#3 B)  capacitor c=3.69574e-18
    C33  (C\#3 B\#2)  capacitor c=1.63731e-18
    C66  (Y\#3 B)  capacitor c=17.4204a
    C68  (Y\#3 B\#2)  capacitor c=6.70737e-19
    C78  (A\#3 B)  capacitor c=6.72e-19
    C85  (B vss)  capacitor c=8.93241e-19
    C88  (B\#2 vss)  capacitor c=17.3686a
    C94  (5 B)  capacitor c=955.524a
    C97  (B\#2 5)  capacitor c=5.81937e-15
    C98  (net1 B)  capacitor c=2.71536e-18
    C111  (X5_5 net1)  capacitor c=319.404a
    C100  (net2\#2 B)  capacitor c=2.57329e-18
    C102  (B\#2 net2\#2)  capacitor c=1.63101e-19
    C115  (net2\#2 X5_5)  capacitor c=319.369a
    C103  (B\#4 X5_5)  capacitor c=521.869a
    C77  (B A)  capacitor c=10.6023a
    C67  (Y\#3 B\#3)  capacitor c=700.599a
    C79  (5 A)  capacitor c=6.70781e-15
    C96  (B\#3 5)  capacitor c=1.99972e-15
    C81  (A\#4 5)  capacitor c=1.44419e-15
    C59  (A\#3 Y\#4)  capacitor c=2.96306e-18
    C57  (Y\#4 A)  capacitor c=103.152a
    C74  (vss\#4 A)  capacitor c=48.9946a
    C58  (Y\#4 A\#4)  capacitor c=169.195a
    C62  (vss\#4 Y\#4)  capacitor c=138.72a
    C75  (vss\#4 A\#4)  capacitor c=191.394a
    C64  (Y\#3 vss\#7)  capacitor c=79.6256a
    C65  (vss\#2 Y\#8)  capacitor c=115.581a
    C87  (vss\#7 B\#3)  capacitor c=190.906a
    C48  (vss\#5 D\#4)  capacitor c=184.211a
    C60  (Y\#6 vss)  capacitor c=103.125a
    C63  (Y\#1 vss\#5)  capacitor c=49.2334a
    MX10_M0_unmatched  (Y\#7 C\#4 vss\#6 vss\#6)  nch w=2e-06 l=1e-06 as=0 \
        ad=5e-12 ps=0 pd=9e-06 sa=2e-06 sb=2e-06
    MX8_M0_unmatched  (Y\#4 A\#4 vss\#4 vss\#4)  nch w=2e-06 l=1e-06 as=0 \
        ad=5e-12 ps=0 pd=9e-06 sa=2e-06 sb=2e-06
    MX9_M0_unmatched  (Y\#8 B\#3 vss\#7 vss\#7)  nch w=2e-06 l=1e-06 as=0 \
        ad=5e-12 ps=0 pd=9e-06 sa=2e-06 sb=2e-06
    MX11_M0_unmatched  (Y\#6 D\#4 vss\#5 vss\#5)  nch w=2e-06 l=1e-06 as=0 \
        ad=5e-12 ps=0 pd=9e-06 sa=2e-06 sb=2e-06
    MX7_M0_unmatched  (Y\#5 D\#2 net3 net3)  pch w=4e-06 l=1e-06 as=0 \
        ad=1e-11 ps=0 pd=1.3e-05 sa=2e-06 sb=2e-06
    MX4_M0_unmatched  (net1\#2 A\#2 vdd\#1 vdd\#1)  pch w=4e-06 l=1e-06 \
        as=0 ad=1e-11 ps=0 pd=1.3e-05 sa=2e-06 sb=2e-06
    MX5_M0_unmatched  (net2\#2 B\#4 net1 net1)  pch w=4e-06 l=1e-06 as=0 \
        ad=1e-11 ps=0 pd=1.3e-05 sa=2e-06 sb=2e-06
    MX6_M0_unmatched  (net3\#2 C\#2 net2 net2)  pch w=4e-06 l=1e-06 as=0 \
        ad=1e-11 ps=0 pd=1.3e-05 sa=2e-06 sb=2e-06
ends NOR4X1
