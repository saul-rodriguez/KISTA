// NAND3X1
simulator lang=spectre insensitive=yes
global vss vdd
subckt NAND3X1 Y C A B
    C9  (vdd\#1 Y\#5)  capacitor c=169.244a
    C22  (C\#2 vss)  capacitor c=6.13654e-18
    C25  (vdd\#1 C\#2)  capacitor c=235.866a
    C31  (C\#2 4)  capacitor c=2.41652e-15
    C48  (4 vss)  capacitor c=14.4681f
    C69  (vdd\#1 4)  capacitor c=5.66442e-15
    C4  (Y\#2 C\#2)  capacitor c=869.502a
    C15  (Y\#2 4)  capacitor c=10.1992f
    C5  (Y\#4 vss)  capacitor c=100.056a
    C2  (Y\#4 C\#4)  capacitor c=168.949a
    C23  (C\#4 vss)  capacitor c=67.5166a
    C32  (C\#4 4)  capacitor c=1.42514e-15
    C13  (Y\#2 B)  capacitor c=16.0854a
    C44  (B vss)  capacitor c=14.8914a
    C76  (4 B)  capacitor c=6.8298e-15
    C14  (Y\#2 B\#2)  capacitor c=821.295a
    C45  (B\#2 vss)  capacitor c=14.7847a
    C77  (B\#2 4)  capacitor c=2.45053e-15
    C16  (Y\#4 net3)  capacitor c=46.0379a
    C35  (C\#4 net3)  capacitor c=83.616a
    C53  (net3 vss)  capacitor c=73.0066a
    C87  (net3 4)  capacitor c=236.848a
    C3  (C\#3 Y)  capacitor c=30.6382a
    C24  (C\#3 vss)  capacitor c=3.09066e-19
    C28  (C\#3 B)  capacitor c=1.32925e-18
    C33  (C\#3 4)  capacitor c=356.597a
    C36  (C\#3 net3)  capacitor c=1.09427e-19
    C37  (C\#2 X5_5)  capacitor c=508.173a
    C18  (Y\#5 X5_5)  capacitor c=406.72a
    C72  (vdd\#1 X5_5)  capacitor c=181.705a
    C1  (C Y)  capacitor c=534.153a
    C12  (B\#3 Y)  capacitor c=3.47772e-19
    C21  (vss C)  capacitor c=13.8513a
    C26  (B C)  capacitor c=20.9718a
    C27  (B\#3 C)  capacitor c=1.32925e-18
    C29  (C\#3 B\#3)  capacitor c=8.42507e-20
    C30  (4 C)  capacitor c=6.33644e-15
    C34  (net3 C)  capacitor c=46.786a
    C17  (Y\#2 net3\#2)  capacitor c=1.56407e-18
    C47  (B\#3 vss)  capacitor c=6.58406e-19
    C54  (net3\#2 vss)  capacitor c=73.7811a
    C79  (B\#3 4)  capacitor c=373.397a
    C88  (net3\#2 4)  capacitor c=238.004a
    C38  (A vss)  capacitor c=6.44656e-18
    C57  (B A)  capacitor c=14.9767a
    C59  (B\#3 A)  capacitor c=4.30674e-19
    C61  (4 A)  capacitor c=6.66157e-15
    C6  (Y\#3 A)  capacitor c=134.368a
    C7  (Y\#3 A\#2)  capacitor c=258.561a
    C39  (A\#2 vss)  capacitor c=9.56069e-18
    C62  (A\#2 4)  capacitor c=1.26397e-15
    C8  (A\#3 Y\#3)  capacitor c=4.94174e-18
    C42  (A\#3 vss)  capacitor c=5.48353e-19
    C58  (A\#3 B)  capacitor c=9.4926e-19
    C80  (net4 B)  capacitor c=12.1712a
    C50  (net4 vss)  capacitor c=74.1313a
    C60  (B\#3 A\#3)  capacitor c=2.72971e-20
    C64  (A\#3 4)  capacitor c=378.269a
    C82  (B\#3 net4)  capacitor c=7.71439e-19
    C46  (B\#4 vss)  capacitor c=74.3598a
    C78  (B\#4 4)  capacitor c=1.45605e-15
    C81  (B\#4 net4)  capacitor c=83.616a
    C83  (net3\#2 B\#4)  capacitor c=83.616a
    C89  (net3\#2 net4)  capacitor c=39.8112a
    C85  (net4 4)  capacitor c=299.333a
    C51  (net4\#2 vss)  capacitor c=66.4358a
    C86  (net4\#2 4)  capacitor c=238.004a
    C63  (A\#4 4)  capacitor c=2.78859e-15
    C65  (net4\#2 A\#4)  capacitor c=83.616a
    C10  (vdd\#4 Y\#6)  capacitor c=201.232a
    C43  (vdd\#4 vss)  capacitor c=20.2528a
    C40  (vss\#1 A)  capacitor c=3.00175e-18
    C55  (vdd\#3 A)  capacitor c=19.3507a
    C11  (vdd\#3 Y\#3)  capacitor c=178.905a
    C41  (vss\#1 A\#4)  capacitor c=174.224a
    C52  (vss\#1 net4\#2)  capacitor c=39.1322a
    C49  (vss\#1 4)  capacitor c=527.615a
    C56  (vdd\#3 A\#2)  capacitor c=238.688a
    C67  (vdd\#4 B\#2)  capacitor c=234.793a
    C70  (vdd\#4 4)  capacitor c=36.9004a
    C71  (vdd\#3 4)  capacitor c=45.4304a
    C68  (4 vdd)  capacitor c=9.036e-15
    C74  (X3_5 vdd)  capacitor c=30.6619a
    C20  (Y\#3 X3_5)  capacitor c=181.705a
    C66  (A\#2 X3_5)  capacitor c=531.582a
    C75  (vdd\#3 X3_5)  capacitor c=406.72a
    C19  (Y\#6 X4_5)  capacitor c=148.996a
    C73  (vdd\#4 X4_5)  capacitor c=148.996a
    C84  (B\#2 X4_5)  capacitor c=531.824a
    MX5_M0_unmatched  (Y\#5 C\#2 vdd\#1 vdd\#1)  pch w=4e-06 l=1e-06 as=0 \
        ad=1e-11 ps=0 pd=1.3e-05 sa=2e-06 sb=2e-06
    MX3_M0_unmatched  (Y\#3 A\#2 vdd\#3 vdd\#3)  pch w=4e-06 l=1e-06 as=0 \
        ad=1e-11 ps=0 pd=1.3e-05 sa=2e-06 sb=2e-06
    MX4_M0_unmatched  (Y\#6 B\#2 vdd\#4 vdd\#4)  pch w=4e-06 l=1e-06 as=0 \
        ad=1e-11 ps=0 pd=1.3e-05 sa=2e-06 sb=2e-06
    Rs1  (4 vss)  resistor r=50
    Rd5  (Y\#5 Y\#2)  resistor r=5.2478
    Rc9  (C\#3 C\#4)  resistor r=1036.0317
    Rc4  (Y Y\#4)  resistor r=5.3
    Rd7  (C\#2 C\#3)  resistor r=2536.0317
    Rd6  (Y Y\#5)  resistor r=5.8521
    Rc1  (Y Y\#2)  resistor r=388.9m
    Rd9  (C\#3 C)  resistor r=85.564
    Rc5  (net3 net3\#2)  resistor r=10.1
    Rd2  (B\#2 B\#3)  resistor r=2536.0317
    Rd4  (B\#3 B)  resistor r=85.564
    Rc13  (Y\#2 Y\#3)  resistor r=2.851
    Rc14  (Y\#2 Y\#6)  resistor r=2.6545
    Rc7  (B\#3 B\#4)  resistor r=1036.0317
    Rc3  (net4 net4\#2)  resistor r=10.1
    Rc6  (A\#2 A\#3)  resistor r=1336.0317
    Rc10  (A\#3 A)  resistor r=85.564
    Rd8  (A\#3 A\#4)  resistor r=2236.0317
    Rc16  (vss\#1 vss)  resistor r=5.0854
    Rd1  (vdd vdd\#3)  resistor r=2.6222
    Rd3  (vdd\#1 vdd\#4)  resistor r=111.9025
    Rc11  (vdd vdd\#1)  resistor r=2.8307
    Rc8  (vdd vdd\#4)  resistor r=2.7532
    MX8_M0_unmatched  (Y\#4 C\#4 net3 net3)  nch w=2e-06 l=1e-06 as=0 \
        ad=5e-12 ps=0 pd=9e-06 sa=2e-06 sb=2e-06
    MX7_M0_unmatched  (net3\#2 B\#4 net4 net4)  nch w=2e-06 l=1e-06 as=0 \
        ad=5e-12 ps=0 pd=9e-06 sa=2e-06 sb=2e-06
    MX6_M0_unmatched  (net4\#2 A\#4 vss\#1 vss\#1)  nch w=2e-06 l=1e-06 \
        as=0 ad=5e-12 ps=0 pd=9e-06 sa=2e-06 sb=2e-06
ends NAND3X1
