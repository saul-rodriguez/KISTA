// DFFRX1
simulator lang=spectre insensitive=yes
global vss vdd
subckt DFFRX1 D Q QN CK RN
    C40  (Y4\#5 vss)  capacitor c=13.2934a
    C374  (Y4\#5 10)  capacitor c=1.25758e-15
    C62  (Y2\#2313 vss)  capacitor c=8.96221e-18
    C360  (Y1\#4 Y4\#4)  capacitor c=270.273a
    C132  (vdd\#2311 Q\#5)  capacitor c=52.1384a
    C21  (CK\#2 vss)  capacitor c=17.849a
    C25  (vdd\#1 vss)  capacitor c=39.0946a
    C29  (RN vss)  capacitor c=40.2212a
    C30  (RN\#2310 vss)  capacitor c=7.29513e-18
    C36  (RN\#2 vss)  capacitor c=4.30999e-18
    C37  (RN\#6 vss)  capacitor c=2.26438e-19
    C39  (Y4 vss)  capacitor c=2.62159e-18
    C42  (Y4\#9 vss)  capacitor c=1.03413e-18
    C48  (Y4\#2311 vss)  capacitor c=59.7365a
    C56  (Y2\#2314 vss)  capacitor c=32.5584a
    C85  (vss\#3 10)  capacitor c=82.5356f
    C159  (QN\#2 CK)  capacitor c=1.07621e-15
    C168  (QN\#2 RN)  capacitor c=1.01608e-15
    C170  (RN\#2 QN\#2)  capacitor c=14.1018a
    C172  (RN\#6 QN\#2)  capacitor c=14.2668a
    C175  (QN\#2 Y4\#7)  capacitor c=2.27019e-19
    C179  (Y2\#2314 QN\#2)  capacitor c=2.12114e-19
    C186  (QN\#2 10)  capacitor c=8.80826e-15
    C201  (RN CK)  capacitor c=1.66583e-15
    C204  (CK\#2 RN)  capacitor c=7.16119e-18
    C206  (RN\#2 CK)  capacitor c=336.543a
    C207  (RN\#2 CK\#2)  capacitor c=5.60037e-18
    C208  (RN\#6 CK)  capacitor c=328.071a
    C209  (RN\#6 CK\#2)  capacitor c=1.0055e-19
    C214  (Y4\#7 CK)  capacitor c=30.2186a
    C219  (Y2\#2314 CK)  capacitor c=18.6603a
    C221  (CK\#2 Y2\#2314)  capacitor c=594.798a
    C226  (10 CK)  capacitor c=16.599f
    C231  (CK\#2 10)  capacitor c=5.5051e-15
    C254  (vdd\#1 RN\#2310)  capacitor c=236.031a
    C257  (vdd\#1 Y4\#9)  capacitor c=187.863a
    C305  (Y4\#7 RN)  capacitor c=424.844a
    C307  (Y4\#9 RN\#2310)  capacitor c=337.167a
    C308  (RN\#2 Y4)  capacitor c=505.847a
    C309  (RN\#6 Y4\#7)  capacitor c=505.852a
    C311  (Y2\#2314 RN)  capacitor c=1.4969e-15
    C313  (RN\#2 Y2\#2314)  capacitor c=643.68a
    C316  (RN\#6 Y2\#2314)  capacitor c=576.995a
    C327  (10 RN)  capacitor c=15.0576f
    C328  (RN\#2310 10)  capacitor c=1.91813e-15
    C335  (RN\#2 10)  capacitor c=5.69841e-15
    C336  (RN\#6 10)  capacitor c=5.55804e-15
    C352  (Y2\#2314 Y4)  capacitor c=1.11763e-15
    C353  (Y2\#2314 Y4\#7)  capacitor c=1.17314e-15
    C378  (Y4\#7 10)  capacitor c=32.6009f
    C412  (Y2\#2314 10)  capacitor c=24.3509f
    C1  (D\#3 vss)  capacitor c=15.5462a
    C109  (D\#3 10)  capacitor c=1.9308e-15
    C2  (D\#2 vss)  capacitor c=8.18989e-18
    C104  (D\#2 RN)  capacitor c=367.819a
    C107  (Y4\#2311 D\#2)  capacitor c=661.777a
    C110  (D\#2 10)  capacitor c=2.81139e-15
    C5  (Q\#6 vss)  capacitor c=13.3087a
    C142  (Y4\#7 Q\#6)  capacitor c=586.574a
    C149  (Q\#6 10)  capacitor c=6.40896e-15
    C6  (Q\#3 vss)  capacitor c=10.458a
    C119  (Q\#3 QN\#2)  capacitor c=6.83013e-19
    C124  (Q\#3 CK)  capacitor c=7.44725e-18
    C126  (CK\#2 Q\#3)  capacitor c=1.38509e-19
    C134  (Q\#3 RN)  capacitor c=7.05318e-18
    C137  (RN\#2 Q\#3)  capacitor c=1.40167e-19
    C143  (Q\#3 Y4\#7)  capacitor c=1.12781e-15
    C145  (Y2\#2314 Q\#3)  capacitor c=1.0444e-15
    C151  (Q\#3 10)  capacitor c=12.5975f
    C7  (Q\#4 vss)  capacitor c=26.2831a
    C8  (vss\#3 Q\#7)  capacitor c=59.7099a
    C123  (Q\#7 CK)  capacitor c=575.86a
    C133  (Q\#7 RN)  capacitor c=570.283a
    C136  (RN\#2 Q\#7)  capacitor c=7.91473e-18
    C139  (RN\#6 Q\#7)  capacitor c=8.00734e-18
    C144  (Y2\#2314 Q\#7)  capacitor c=565.58a
    C150  (Q\#7 10)  capacitor c=4.05128e-15
    C10  (QN vss)  capacitor c=18.3077a
    C116  (Q\#6 QN)  capacitor c=831.792a
    C118  (Q\#3 QN)  capacitor c=75.859a
    C174  (Y4\#7 QN)  capacitor c=1.37896e-15
    C176  (Y2\#2314 QN)  capacitor c=1.04424e-15
    C183  (10 QN)  capacitor c=9.66853e-15
    C11  (QN\#4 vss)  capacitor c=12.174a
    C173  (QN\#4 Y4)  capacitor c=586.713a
    C177  (Y2\#2314 QN\#4)  capacitor c=18.538a
    C184  (QN\#4 10)  capacitor c=3.67817e-15
    C12  (QN\#6 vss)  capacitor c=6.84303e-18
    C187  (QN\#6 10)  capacitor c=78.8258a
    C13  (QN\#7 vss)  capacitor c=15.8182a
    C188  (QN\#7 10)  capacitor c=618.171a
    C14  (QN\#2310 vss)  capacitor c=9.97868e-18
    C189  (QN\#2310 10)  capacitor c=315.872a
    C15  (vss\#3 QN\#5)  capacitor c=73.7603a
    C120  (QN\#5 Q\#7)  capacitor c=80.8146a
    C160  (QN\#5 CK)  capacitor c=68.4719a
    C190  (QN\#5 10)  capacitor c=221.122a
    C17  (vss\#5 QN\#2)  capacitor c=617.225a
    C9  (vss\#5 Q\#2)  capacitor c=155.49a
    C122  (Q\#2 QN\#2)  capacitor c=97.0997a
    C125  (Q\#2 CK)  capacitor c=1.12235e-15
    C127  (CK\#2 Q\#2)  capacitor c=19.6909a
    C135  (Q\#2 RN)  capacitor c=1.00271e-15
    C138  (RN\#2 Q\#2)  capacitor c=19.9267a
    C140  (RN\#6 Q\#2)  capacitor c=14.178a
    C152  (Q\#2 10)  capacitor c=10.039f
    C16  (vss\#5 QN\#3)  capacitor c=481.277a
    C121  (Q\#2 QN\#3)  capacitor c=138.857a
    C158  (QN\#3 CK)  capacitor c=561.315a
    C161  (CK\#2 QN\#3)  capacitor c=9.85178e-18
    C167  (QN\#3 RN)  capacitor c=564.176a
    C169  (RN\#2 QN\#3)  capacitor c=14.6156a
    C171  (RN\#6 QN\#3)  capacitor c=7.92159e-18
    C178  (Y2\#2314 QN\#3)  capacitor c=497.876a
    C185  (QN\#3 10)  capacitor c=5.54369e-15
    C192  (net5\#2 QN\#2)  capacitor c=1.83462e-18
    C94  (vss\#3 net5\#2)  capacitor c=72.6564a
    C154  (net5\#2 Q\#7)  capacitor c=83.616a
    C193  (QN\#5 net5\#2)  capacitor c=39.8112a
    C148  (Y2\#20 Q\#7)  capacitor c=20.2321a
    C67  (Y2\#20 vss)  capacitor c=5.65137e-19
    C244  (net5\#2 CK)  capacitor c=68.4915a
    C318  (Y2\#20 RN)  capacitor c=71.7265a
    C319  (Y2\#20 RN\#2)  capacitor c=9.95464e-19
    C320  (Y2\#20 RN\#6)  capacitor c=43.1559a
    C358  (Y2\#20 Y4\#7)  capacitor c=72.9681a
    C417  (Y2\#20 10)  capacitor c=683.042a
    C465  (net5\#2 10)  capacitor c=221.343a
    C93  (vss\#3 net5)  capacitor c=73.7603a
    C243  (net5 CK)  capacitor c=68.4719a
    C464  (net5 10)  capacitor c=221.122a
    C18  (CK\#6 vss)  capacitor c=23.1835a
    C215  (Y4\#7 CK\#6)  capacitor c=499.966a
    C227  (CK\#6 10)  capacitor c=3.02001e-15
    C19  (CK\#4 vss)  capacitor c=23.1294a
    C213  (CK\#4 Y4)  capacitor c=586.447a
    C228  (CK\#4 10)  capacitor c=3.03501e-15
    C20  (vss\#8 CK)  capacitor c=331.574a
    C22  (CK\#7 vss)  capacitor c=9.24328e-19
    C210  (CK\#7 RN)  capacitor c=44.0604a
    C211  (CK\#7 RN\#2)  capacitor c=6.11498e-19
    C212  (CK\#7 RN\#6)  capacitor c=6.18653e-19
    C216  (CK\#7 Y4\#7)  capacitor c=1.95288e-18
    C232  (CK\#7 10)  capacitor c=397.19a
    C23  (vss\#3 CK\#8)  capacitor c=66.2249a
    C229  (CK\#8 10)  capacitor c=776.482a
    C250  (CK\#7 net11)  capacitor c=7.09208e-18
    C97  (vss\#3 net11)  capacitor c=73.7603a
    C247  (net11 CK)  capacitor c=63.8165a
    C248  (CK\#8 net11)  capacitor c=83.616a
    C468  (net11 10)  capacitor c=221.122a
    C24  (vss\#5 CK\#3)  capacitor c=67.0147a
    C230  (CK\#3 10)  capacitor c=754.181a
    C26  (vdd\#2316 vss)  capacitor c=39.3791a
    C103  (vdd\#2316 D\#3)  capacitor c=234.958a
    C27  (vdd\#21 vss)  capacitor c=38.3698a
    C162  (QN\#6 vdd\#21)  capacitor c=144.572a
    C28  (vdd\#9 vss)  capacitor c=64.0004a
    C130  (vdd\#9 Q\#6)  capacitor c=1.21782e-15
    C31  (RN\#8 vss)  capacitor c=18.2604a
    C166  (RN\#8 QN)  capacitor c=821.924a
    C306  (Y4\#7 RN\#8)  capacitor c=26.0672a
    C329  (RN\#8 10)  capacitor c=2.47734e-15
    C32  (RN\#4 vss)  capacitor c=20.0446a
    C303  (RN\#4 Y4)  capacitor c=26.0672a
    C330  (RN\#4 10)  capacitor c=2.47673e-15
    C38  (vss\#3 RN\#7)  capacitor c=61.2095a
    C202  (RN\#7 CK)  capacitor c=282.784a
    C332  (RN\#7 10)  capacitor c=1.36089e-15
    C338  (RN\#7 net5)  capacitor c=83.616a
    C41  (Y4\#4 vss)  capacitor c=2.22023e-18
    C375  (Y4\#4 10)  capacitor c=1.21603e-15
    C43  (Y4\#2313 vss)  capacitor c=3.55018e-18
    C106  (Y4\#2313 D\#3)  capacitor c=340.298a
    C258  (vdd\#2316 Y4\#2313)  capacitor c=125.923a
    C386  (Y4\#9 X36_5)  capacitor c=406.72a
    C287  (vdd\#1 X36_5)  capacitor c=181.705a
    C348  (RN\#2310 X36_5)  capacitor c=508.173a
    C262  (vdd\#2 Y4\#2313)  capacitor c=50.1421a
    C310  (Y4\#2311 RN\#2311)  capacitor c=647.161a
    C331  (RN\#2311 10)  capacitor c=2.24664e-15
    C115  (D\#3 X35_5)  capacitor c=531.824a
    C288  (vdd\#2316 X35_5)  capacitor c=148.996a
    C387  (Y4\#2313 X35_5)  capacitor c=148.996a
    C33  (vss\#1 RN\#2311)  capacitor c=111.117a
    C49  (Y4\#2311 vss\#1)  capacitor c=50.5731a
    C3  (vss\#1 D)  capacitor c=70.1673a
    C108  (10 D)  capacitor c=746.272a
    C4  (vss\#1 D\#1)  capacitor c=30.8197a
    C105  (D\#1 RN)  capacitor c=295.851a
    C111  (D\#1 10)  capacitor c=3.63686e-15
    C114  (net2\#2 D\#1)  capacitor c=1.83588e-18
    C102  (net2\#2 vss)  capacitor c=1.12473e-18
    C113  (net2\#2 D\#2)  capacitor c=83.616a
    C347  (net2\#2 RN)  capacitor c=51.0237a
    C385  (Y4\#2311 net2\#2)  capacitor c=64.1885a
    C475  (net2\#2 10)  capacitor c=233.242a
    C34  (vss\#1 RN\#9)  capacitor c=185.942a
    C334  (RN\#9 10)  capacitor c=2.63393e-15
    C346  (RN\#9 net2)  capacitor c=77.6958a
    C101  (vss\#1 net2)  capacitor c=46.0379a
    C345  (RN\#2311 net2)  capacitor c=83.616a
    C384  (Y4\#2311 net2)  capacitor c=68.4719a
    C474  (net2 10)  capacitor c=233.966a
    C343  (RN\#2311 net1)  capacitor c=1.12473e-18
    C112  (D\#2 net1)  capacitor c=83.616a
    C479  (net2\#2 net1)  capacitor c=39.8112a
    C342  (net1 RN)  capacitor c=68.4719a
    C382  (Y4\#2311 net1)  capacitor c=68.4524a
    C472  (net1 10)  capacitor c=233.966a
    C344  (net1\#2 RN)  capacitor c=68.4915a
    C383  (Y4\#2311 net1\#2)  capacitor c=104.445a
    C473  (net1\#2 10)  capacitor c=234.2a
    C44  (Y4\#2314 vss)  capacitor c=3.19102e-18
    C45  (Y4\#2315 vss)  capacitor c=2.49485e-18
    C450  (net1\#2 Y3\#2316)  capacitor c=83.616a
    C75  (Y3\#2316 vss)  capacitor c=2.2407e-18
    C321  (Y3\#2316 RN)  capacitor c=603.504a
    C371  (Y4\#2311 Y3\#2316)  capacitor c=422.842a
    C441  (Y3\#2316 10)  capacitor c=2.48754e-15
    C47  (Y4\#2 vss)  capacitor c=7.6669e-18
    C379  (Y4\#2 10)  capacitor c=5.46141e-15
    C50  (vss\#3 Y4\#8)  capacitor c=70.2146a
    C304  (Y4\#8 RN)  capacitor c=292.281a
    C376  (Y4\#8 10)  capacitor c=2.82691e-15
    C51  (Y2 vss)  capacitor c=2.7504e-18
    C351  (Y2 Y4)  capacitor c=94.3721a
    C52  (Y2\#2319 vss)  capacitor c=21.9809a
    C406  (Y2\#2319 10)  capacitor c=1.81616e-15
    C53  (Y2\#2317 vss)  capacitor c=11.6026a
    C146  (Q\#4 Y2\#2317)  capacitor c=815.244a
    C407  (Y2\#2317 10)  capacitor c=1.80605e-15
    C54  (Y2\#5 vss)  capacitor c=12.2971a
    C408  (Y2\#5 10)  capacitor c=603.937a
    C55  (Y2\#4 vss)  capacitor c=8.15587e-19
    C411  (Y2\#4 10)  capacitor c=1.32015e-15
    C57  (Y2\#7 vss)  capacitor c=212.284a
    C413  (Y2\#7 10)  capacitor c=3.18803e-15
    C58  (vss\#7 Y2\#21)  capacitor c=181.775a
    C98  (vss\#3 net11\#2)  capacitor c=105.129a
    C217  (Y2\#21 CK)  capacitor c=578.285a
    C249  (net11\#2 CK)  capacitor c=65.504a
    C409  (Y2\#21 10)  capacitor c=1.9461e-15
    C424  (net11\#2 Y2\#21)  capacitor c=83.616a
    C469  (net11\#2 10)  capacitor c=221.343a
    C60  (Y2\#9 vss)  capacitor c=3.25958e-18
    C147  (Y2\#9 Q\#4)  capacitor c=99.1849a
    C312  (Y2\#9 RN\#4)  capacitor c=814.91a
    C354  (Y2\#9 Y4)  capacitor c=67.1879a
    C61  (Y2\#2312 vss)  capacitor c=9.6027e-18
    C63  (Y2\#8 vss)  capacitor c=1.39853e-18
    C64  (Y2\#2 vss)  capacitor c=7.5202e-18
    C355  (Y2\#2 Y4)  capacitor c=317.784a
    C414  (Y2\#2 10)  capacitor c=3.54381e-15
    C65  (Y2\#3 vss)  capacitor c=4.96615e-18
    C222  (CK\#2 Y2\#3)  capacitor c=5.56464e-18
    C356  (Y2\#3 Y4)  capacitor c=317.516a
    C415  (Y2\#3 10)  capacitor c=3.99931e-15
    C397  (Y2\#2 Y1\#6)  capacitor c=151.857a
    C394  (Y1\#6 Y2)  capacitor c=51.6335a
    C395  (Y1\#6 Y2\#5)  capacitor c=189.694a
    C399  (Y1\#3 Y2\#3)  capacitor c=333.626a
    C362  (Y1\#3 Y4\#2)  capacitor c=1.14189e-15
    C361  (Y1\#3 Y4\#3)  capacitor c=301.765a
    C377  (Y4\#3 10)  capacitor c=2.60616e-15
    C398  (Y1\#3 Y2\#4)  capacitor c=422.744a
    C433  (Y1\#3 10)  capacitor c=14.1233f
    C46  (vss\#6 Y4\#3)  capacitor c=185.683a
    C71  (Y1\#3 vss\#6)  capacitor c=12.5365a
    C380  (net7\#2 Y4\#3)  capacitor c=96.4172a
    C86  (net7\#2 vss)  capacitor c=188.88a
    C420  (net7\#2 Y2\#7)  capacitor c=140.014a
    C457  (net7\#2 10)  capacitor c=919.612a
    C418  (Y2\#4 net7)  capacitor c=109.895a
    C396  (Y1\#5 Y2\#7)  capacitor c=54.7346a
    C421  (net9\#2 Y2\#7)  capacitor c=34.8346a
    C87  (net9\#2 vss)  capacitor c=2.80012e-18
    C234  (net9\#2 CK)  capacitor c=11.4835a
    C235  (CK\#2 net9\#2)  capacitor c=10.5485a
    C419  (Y2\#8 net7)  capacitor c=6.07959e-18
    C422  (Y2\#8 net9\#2)  capacitor c=83.4762a
    C434  (Y1\#3 net7)  capacitor c=113.087a
    C456  (net7 10)  capacitor c=460.267a
    C459  (net9\#2 10)  capacitor c=915.566a
    C68  (Y1 vss)  capacitor c=32.8928a
    C359  (Y1 Y4)  capacitor c=791.232a
    C391  (Y2\#2314 Y1)  capacitor c=717.606a
    C392  (Y2\#8 Y1)  capacitor c=76.8586a
    C66  (Y2\#2315 vss)  capacitor c=3.22647e-18
    C314  (Y2\#2315 RN)  capacitor c=561.941a
    C315  (Y2\#2315 RN\#2)  capacitor c=14.5577a
    C317  (RN\#6 Y2\#2315)  capacitor c=7.89022e-18
    C357  (Y2\#2315 Y4)  capacitor c=598.049a
    C141  (Y4 Q)  capacitor c=247.626a
    C117  (QN\#4 Q)  capacitor c=821.858a
    C416  (Y2\#2315 10)  capacitor c=5.46766e-15
    C218  (Y2\#2316 CK)  capacitor c=566.061a
    C220  (CK\#2 Y2\#2316)  capacitor c=9.93509e-18
    C410  (Y2\#2316 10)  capacitor c=1.94715e-15
    C131  (vdd\#2311 Q\#3)  capacitor c=333.906a
    C286  (vdd\#2311 10)  capacitor c=78.4996f
    C59  (vss\#9 Y2\#2316)  capacitor c=181.872a
    C423  (net4\#2 Y2\#2316)  capacitor c=83.616a
    C92  (vss\#5 net4\#2)  capacitor c=105.129a
    C241  (net4\#2 CK)  capacitor c=67.3101a
    C242  (CK\#2 net4\#2)  capacitor c=2.36242e-18
    C463  (net4\#2 10)  capacitor c=221.343a
    C91  (vss\#5 net4)  capacitor c=72.6356a
    C153  (Q\#2 net4)  capacitor c=41.34a
    C191  (QN\#3 net4)  capacitor c=83.616a
    C240  (net4 CK)  capacitor c=67.2909a
    C462  (net4 10)  capacitor c=221.122a
    C69  (Y1\#7 vss)  capacitor c=13.3102a
    C431  (Y1\#7 10)  capacitor c=2.47005e-15
    C70  (Y1\#9 vss)  capacitor c=16.1555a
    C393  (Y2\#8 Y1\#9)  capacitor c=114.863a
    C432  (Y1\#9 10)  capacitor c=831.738a
    C435  (net9\#2 Y1\#9)  capacitor c=115.324a
    C88  (vss\#5 net9)  capacitor c=150.186a
    C233  (CK\#3 net9)  capacitor c=84.7217a
    C458  (net9 10)  capacitor c=451.872a
    C72  (Y3 vss)  capacitor c=3.10197e-18
    C180  (Y3 QN)  capacitor c=11.4079a
    C363  (Y4\#7 Y3)  capacitor c=172.952a
    C401  (Y2\#2319 Y3)  capacitor c=738.122a
    C402  (Y2\#2314 Y3)  capacitor c=19.8045a
    C403  (Y3\#2 Y2\#2314)  capacitor c=538.685a
    C80  (Y3\#2 vss)  capacitor c=9.87803e-18
    C182  (Y3\#2 QN)  capacitor c=11.9237a
    C196  (X28_5 QN)  capacitor c=9.91316e-18
    C155  (Q\#6 X28_5)  capacitor c=528.86a
    C164  (vdd\#23 QN\#2310)  capacitor c=156.453a
    C197  (QN\#2310 X28_5)  capacitor c=210.804a
    C295  (vdd\#23 X28_5)  capacitor c=151.147a
    C367  (Y3\#2 Y4\#7)  capacitor c=600.65a
    C404  (Y2\#20 Y3)  capacitor c=1.50138e-18
    C405  (Y2\#20 Y3\#2)  capacitor c=40.8379a
    C444  (Y3\#2 10)  capacitor c=5.41661e-15
    C73  (Y3\#2314 vss)  capacitor c=12.26a
    C364  (Y4\#2314 Y3\#2314)  capacitor c=189.659a
    C439  (Y3\#2314 10)  capacitor c=603.558a
    C74  (Y3\#4 vss)  capacitor c=8.64028e-18
    C181  (QN\#6 Y3\#4)  capacitor c=139.36a
    C281  (vdd\#21 Y3\#4)  capacitor c=236.009a
    C440  (Y3\#4 10)  capacitor c=615.039a
    C79  (vss\#8 Y3\#3)  capacitor c=181.775a
    C455  (Y3\#4 X30_5)  capacitor c=503.965a
    C194  (QN\#6 X30_5)  capacitor c=318.488a
    C238  (net10\#2 CK\#3)  capacitor c=83.616a
    C476  (net10\#2 net9)  capacitor c=39.0399a
    C251  (net12\#2 CK\#8)  capacitor c=83.616a
    C478  (net12\#2 net11)  capacitor c=39.8112a
    C339  (net6\#2 RN\#7)  capacitor c=83.616a
    C477  (net6\#2 net5)  capacitor c=39.8112a
    C368  (Y3\#9 Y4\#7)  capacitor c=893.519a
    C372  (Y4\#2311 Y3\#9)  capacitor c=530.394a
    C373  (Y4\#2311 Y3\#2315)  capacitor c=40.4975a
    C205  (CK\#2 RN\#3)  capacitor c=5.04682e-18
    C239  (CK\#2 net10\#2)  capacitor c=15.2733a
    C325  (RN\#2 Y3\#3)  capacitor c=7.73281e-18
    C326  (RN\#6 Y3\#3)  capacitor c=7.82329e-18
    C340  (RN\#6 net6\#2)  capacitor c=1.83588e-18
    C270  (vdd\#29 Y2)  capacitor c=19.7488a
    C259  (vdd\#2317 Y4\#2314)  capacitor c=78.277a
    C277  (vdd\#2317 Y3\#2314)  capacitor c=234.766a
    C263  (vdd\#4 Y4\#2314)  capacitor c=53.0681a
    C283  (Y3\#9 vdd\#2317)  capacitor c=23.657a
    C369  (Y3\#9 Y4\#2314)  capacitor c=51.5896a
    C388  (Y4\#2314 X34_5)  capacitor c=188.398a
    C289  (vdd\#2317 X34_5)  capacitor c=162.469a
    C451  (Y3\#2314 X34_5)  capacitor c=533.577a
    C284  (Y3\#2315 vdd\#2317)  capacitor c=2.31801e-18
    C81  (Y3\#9 vss)  capacitor c=27.1314a
    C82  (Y3\#2315 vss)  capacitor c=5.33948e-19
    C76  (Y3\#2311 vss)  capacitor c=9.30753e-18
    C285  (vdd\#4 Y3\#2311)  capacitor c=52.1384a
    C77  (Y3\#2312 vss)  capacitor c=9.6027e-18
    C78  (Y3\#2313 vss)  capacitor c=3.39673e-18
    C225  (Y3\#9 CK\#6)  capacitor c=819.561a
    C199  (vdd\#2319 CK\#6)  capacitor c=234.793a
    C279  (Y3\#2312 vdd\#2319)  capacitor c=204.098a
    C252  (CK\#6 X32_5)  capacitor c=531.824a
    C453  (Y3\#2312 X32_5)  capacitor c=148.996a
    C291  (vdd\#2319 X32_5)  capacitor c=148.996a
    C278  (vdd\#2318 Y3\#2311)  capacitor c=103.525a
    C260  (vdd\#2318 Y4\#5)  capacitor c=234.633a
    C365  (Y3\#2311 Y4\#5)  capacitor c=244.616a
    C370  (Y3\#2315 Y4\#5)  capacitor c=1.17121e-19
    C290  (vdd\#2318 X33_5)  capacitor c=162.469a
    C452  (Y3\#2311 X33_5)  capacitor c=188.398a
    C389  (Y4\#5 X33_5)  capacitor c=510.168a
    C280  (Y3\#2313 vdd\#20)  capacitor c=204.098a
    C264  (vdd\#20 Y2\#2319)  capacitor c=234.793a
    C292  (vdd\#20 X31_5)  capacitor c=148.996a
    C425  (Y2\#2319 X31_5)  capacitor c=531.824a
    C454  (Y3\#2313 X31_5)  capacitor c=149.738a
    C282  (vdd\#21 Y3\#2313)  capacitor c=67.3944a
    C293  (vdd\#21 X30_5)  capacitor c=188.398a
    C366  (Y3\#6 Y4\#8)  capacitor c=80.8146a
    C84  (vss\#3 Y3\#6)  capacitor c=73.7811a
    C83  (vss\#3 Y3\#5)  capacitor c=141.732a
    C95  (vss\#3 net6)  capacitor c=105.108a
    C96  (vss\#3 net6\#2)  capacitor c=73.7811a
    C99  (vss\#3 net12)  capacitor c=72.6356a
    C100  (vss\#3 net12\#2)  capacitor c=73.7811a
    C381  (Y4\#8 net12)  capacitor c=83.616a
    C448  (Y3\#5 net12)  capacitor c=1.50952e-18
    C449  (Y3\#6 net12)  capacitor c=39.8112a
    C324  (Y3\#6 RN)  capacitor c=10.3204a
    C323  (Y3\#5 RN)  capacitor c=12.9436a
    C341  (net12 RN)  capacitor c=20.635a
    C322  (Y3\#3 RN)  capacitor c=557.175a
    C447  (Y3\#3 net6)  capacitor c=83.616a
    C470  (net12 10)  capacitor c=234.991a
    C442  (Y3\#3 10)  capacitor c=3.17729e-15
    C443  (Y3\#5 10)  capacitor c=4.20922e-15
    C445  (Y3\#9 10)  capacitor c=10.0237f
    C446  (Y3\#2315 10)  capacitor c=270.61a
    C466  (net6 10)  capacitor c=221.122a
    C245  (net6 CK)  capacitor c=68.4719a
    C224  (Y3\#3 CK)  capacitor c=575.996a
    C246  (net6\#2 CK)  capacitor c=60.7985a
    C467  (net6\#2 10)  capacitor c=220.425a
    C471  (net12\#2 10)  capacitor c=235.227a
    C203  (RN\#3 CK)  capacitor c=287.548a
    C333  (RN\#3 10)  capacitor c=1.38264e-15
    C35  (vss\#2310 RN\#3)  capacitor c=181.691a
    C237  (net10\#2 CK)  capacitor c=53.8679a
    C236  (net10 CK)  capacitor c=67.2909a
    C337  (RN\#3 net10)  capacitor c=83.616a
    C460  (net10 10)  capacitor c=221.122a
    C461  (net10\#2 10)  capacitor c=221.343a
    C89  (vss\#5 net10)  capacitor c=105.108a
    C90  (vss\#5 net10\#2)  capacitor c=72.6564a
    C128  (vdd\#24 Q\#5)  capacitor c=91.3a
    C156  (Q\#5 X27_5)  capacitor c=169.256a
    C165  (vdd\#24 QN\#4)  capacitor c=303.376a
    C198  (QN\#4 X27_5)  capacitor c=522.459a
    C296  (vdd\#24 X27_5)  capacitor c=154.377a
    C163  (QN\#7 vdd\#22)  capacitor c=230.088a
    C195  (QN\#7 X29_5)  capacitor c=445.838a
    C255  (vdd\#22 RN\#8)  capacitor c=235.844a
    C294  (vdd\#22 X29_5)  capacitor c=188.398a
    C349  (RN\#8 X29_5)  capacitor c=510.168a
    C129  (Q\#4 vdd\#25)  capacitor c=213.317a
    C157  (Q\#4 X26_5)  capacitor c=162.469a
    C265  (vdd\#25 Y2\#2317)  capacitor c=235.812a
    C297  (vdd\#25 X26_5)  capacitor c=188.398a
    C426  (Y2\#2317 X26_5)  capacitor c=533.577a
    C256  (vdd\#26 RN\#4)  capacitor c=235.812a
    C266  (Y2\#9 vdd\#26)  capacitor c=213.316a
    C298  (vdd\#26 X25_5)  capacitor c=188.398a
    C350  (RN\#4 X25_5)  capacitor c=510.168a
    C427  (Y2\#9 X25_5)  capacitor c=162.469a
    C223  (Y2\#2310 CK\#4)  capacitor c=821.827a
    C200  (vdd\#27 CK\#4)  capacitor c=234.793a
    C253  (CK\#4 X24_5)  capacitor c=531.824a
    C267  (vdd\#27 Y2\#2312)  capacitor c=151.96a
    C299  (vdd\#27 X24_5)  capacitor c=148.996a
    C428  (Y2\#2312 X24_5)  capacitor c=148.996a
    C272  (vdd\#2313 Y2\#2312)  capacitor c=52.1384a
    C400  (Y2\#2310 Y1\#7)  capacitor c=828.65a
    C273  (vdd\#28 Y1\#7)  capacitor c=234.633a
    C268  (Y2\#2313 vdd)  capacitor c=52.1384a
    C269  (vdd\#28 Y2\#2313)  capacitor c=104.314a
    C300  (vdd\#28 X23_5)  capacitor c=162.469a
    C429  (Y2\#2313 X23_5)  capacitor c=188.398a
    C436  (Y1\#7 X23_5)  capacitor c=533.577a
    C271  (vdd\#29 Y2\#5)  capacitor c=234.798a
    C274  (Y1\#6 vdd)  capacitor c=49.2406a
    C275  (vdd\#29 Y1\#6)  capacitor c=78.277a
    C301  (vdd\#29 X22_5)  capacitor c=162.469a
    C430  (Y2\#5 X22_5)  capacitor c=510.168a
    C437  (Y1\#6 X22_5)  capacitor c=188.398a
    C261  (vdd\#2315 Y4\#4)  capacitor c=235.866a
    C276  (Y1\#4 vdd\#2315)  capacitor c=223.193a
    C302  (vdd\#2315 X21_5)  capacitor c=181.705a
    C390  (Y4\#4 X21_5)  capacitor c=531.582a
    C438  (Y1\#4 X21_5)  capacitor c=406.72a
    MX36_M0_unmatched  (Y4\#9 RN\#2310 vdd\#1 vdd\#1)  pch w=4e-06 l=1e-06 \
        as=0 ad=1e-11 ps=0 pd=1.3e-05 sa=2e-06 sb=2e-06
    MX35_M0_unmatched  (Y4\#2313 D\#3 vdd\#2316 vdd\#2316)  pch w=4e-06 \
        l=1e-06 as=0 ad=1e-11 ps=0 pd=1.3e-05 sa=2e-06 sb=2e-06
    MX28_M0_unmatched  (QN\#2310 Q\#6 vdd\#23 vdd\#23)  pch w=4e-06 \
        l=1e-06 as=0 ad=1e-11 ps=0 pd=1.3e-05 sa=2e-06 sb=2e-06
    MX30_M0_unmatched  (QN\#6 Y3\#4 vdd\#21 vdd\#21)  pch w=4e-06 l=1e-06 \
        as=0 ad=1e-11 ps=0 pd=1.3e-05 sa=2e-06 sb=2e-06
    MX34_M0_unmatched  (Y4\#2314 Y3\#2314 vdd\#2317 vdd\#2317)  pch \
        w=4e-06 l=1e-06 as=0 ad=1e-11 ps=0 pd=1.3e-05 sa=2e-06 sb=2e-06
    MX32_M0_unmatched  (Y3\#2312 CK\#6 vdd\#2319 vdd\#2319)  pch w=4e-06 \
        l=1e-06 as=0 ad=1e-11 ps=0 pd=1.3e-05 sa=2e-06 sb=2e-06
    MX33_M0_unmatched  (Y3\#2311 Y4\#5 vdd\#2318 vdd\#2318)  pch w=4e-06 \
        l=1e-06 as=0 ad=1e-11 ps=0 pd=1.3e-05 sa=2e-06 sb=2e-06
    MX31_M0_unmatched  (Y3\#2313 Y2\#2319 vdd\#20 vdd\#20)  pch w=4e-06 \
        l=1e-06 as=0 ad=1e-11 ps=0 pd=1.3e-05 sa=2e-06 sb=2e-06
    MX27_M0_unmatched  (Q\#5 QN\#4 vdd\#24 vdd\#24)  pch w=4e-06 l=1e-06 \
        as=0 ad=1e-11 ps=0 pd=1.3e-05 sa=2e-06 sb=2e-06
    MX29_M0_unmatched  (QN\#7 RN\#8 vdd\#22 vdd\#22)  pch w=4e-06 l=1e-06 \
        as=0 ad=1e-11 ps=0 pd=1.3e-05 sa=2e-06 sb=2e-06
    MX26_M0_unmatched  (Q\#4 Y2\#2317 vdd\#25 vdd\#25)  pch w=4e-06 \
        l=1e-06 as=0 ad=1e-11 ps=0 pd=1.3e-05 sa=2e-06 sb=2e-06
    MX25_M0_unmatched  (Y2\#9 RN\#4 vdd\#26 vdd\#26)  pch w=4e-06 l=1e-06 \
        as=0 ad=1e-11 ps=0 pd=1.3e-05 sa=2e-06 sb=2e-06
    MX24_M0_unmatched  (Y2\#2312 CK\#4 vdd\#27 vdd\#27)  pch w=4e-06 \
        l=1e-06 as=0 ad=1e-11 ps=0 pd=1.3e-05 sa=2e-06 sb=2e-06
    MX23_M0_unmatched  (Y2\#2313 Y1\#7 vdd\#28 vdd\#28)  pch w=4e-06 \
        l=1e-06 as=0 ad=1e-11 ps=0 pd=1.3e-05 sa=2e-06 sb=2e-06
    MX22_M0_unmatched  (Y1\#6 Y2\#5 vdd\#29 vdd\#29)  pch w=4e-06 l=1e-06 \
        as=0 ad=1e-11 ps=0 pd=1.3e-05 sa=2e-06 sb=2e-06
    MX21_M0_unmatched  (Y1\#4 Y4\#4 vdd\#2315 vdd\#2315)  pch w=4e-06 \
        l=1e-06 as=0 ad=1e-11 ps=0 pd=1.3e-05 sa=2e-06 sb=2e-06
    Rc14  (Y2 Y2\#2313)  resistor r=5.5331
    Rc27  (Y1\#3 Y1\#4)  resistor r=2.6731
    Rc32  (Q Q\#5)  resistor r=2.675
    Rd4  (RN\#2 RN\#6)  resistor r=6329.8921
    Rd8  (RN\#6 RN)  resistor r=87.8501
    Rd45  (CK\#2 CK)  resistor r=86.964
    Rd25  (Y4 Y4\#7)  resistor r=2.5
    Rd26  (Y4\#7 Y4\#2311)  resistor r=0.298
    Rc82  (RN\#2 RN)  resistor r=88.878
    Rc55  (Y4\#9 Y4\#2311)  resistor r=3.3574
    Rs1  (10 vss)  resistor r=50
    Rd48  (D\#2 D\#3)  resistor r=1800
    Rc25  (Q\#6 Q\#3)  resistor r=2323.2666
    Rc24  (Q\#6 Q\#7)  resistor r=3600
    Rc84  (QN\#2 QN)  resistor r=1494.3964
    Rd20  (QN QN\#6)  resistor r=3.0609
    Rd19  (QN QN\#7)  resistor r=3.0009
    Rc69  (QN\#6 QN\#7)  resistor r=30.254
    Rd34  (QN QN\#2310)  resistor r=2.7528
    Rc85  (QN\#2 QN\#2310)  resistor r=40443.4648
    Rd21  (QN\#2 QN\#5)  resistor r=10.1
    Rc63  (vss vss\#5)  resistor r=299.7m
    Rc64  (vss\#3 vss\#5)  resistor r=0.401
    Rc33  (Q\#3 Q\#2)  resistor r=1445.953
    Rd5  (QN\#3 QN\#4)  resistor r=3600
    Rc68  (QN\#3 QN\#2)  resistor r=1723.2665
    Rc21  (net5 net5\#2)  resistor r=10.1
    Rc2  (Y2\#2314 Y2\#20)  resistor r=86.564
    Rc70  (CK\#2 CK\#4)  resistor r=3136.0317
    Rc62  (vss\#3 vss\#8)  resistor r=5.0974
    Rc86  (CK\#6 CK\#7)  resistor r=3136.0317
    Rc71  (CK\#7 CK)  resistor r=85.664
    Rd35  (CK\#7 CK\#8)  resistor r=436.0318
    Rd36  (CK\#2 CK\#3)  resistor r=436.0318
    Rc67  (RN\#6 RN\#8)  resistor r=2536.0317
    Rd7  (RN\#2 RN\#4)  resistor r=2536.0317
    Rd6  (RN\#6 RN\#7)  resistor r=1036.0317
    Rc49  (Y4\#9 Y4\#2313)  resistor r=47.1422
    Rd9  (RN\#2310 RN\#2311)  resistor r=1800
    Rc72  (vdd\#1 vdd\#2)  resistor r=2.6962
    Rd32  (vdd\#2 vdd\#2316)  resistor r=2.6224
    Rc54  (Y4\#2313 Y4\#2311)  resistor r=3.1338
    Rc48  (vss\#1 vss\#3)  resistor r=5.8408
    Rc44  (D D\#1)  resistor r=0.1
    Rd47  (D\#1 D\#2)  resistor r=1081.957
    Rc95  (RN\#2311 RN\#9)  resistor r=476.9571
    Rc83  (RN\#9 RN)  resistor r=5.1
    Rc45  (net2 net2\#2)  resistor r=10.1
    Rc46  (vss\#1 vss\#7)  resistor r=911.2365
    Rc43  (net1 net1\#2)  resistor r=10.1
    Rc47  (vss\#7 vss\#3)  resistor r=5.1589
    Rc50  (Y4\#2311 Y4\#2314)  resistor r=2.7545
    Rc52  (Y4\#2311 Y4\#2315)  resistor r=7.6419
    Rc56  (Y4\#7 Y4\#2315)  resistor r=15.74
    Rd12  (Y4\#2 Y4\#4)  resistor r=1336.0317
    Rd11  (Y4\#2 Y4)  resistor r=85.464
    Rd28  (Y2\#20 Y2\#2319)  resistor r=1936.0317
    Rd18  (Y2\#4 Y2\#7)  resistor r=481.9571
    Rc10  (Y2\#20 Y2\#21)  resistor r=1636.0317
    Rc31  (net11 net11\#2)  resistor r=10.1
    Rd24  (Y2\#7 Y2\#8)  resistor r=5.1779
    Rd17  (Y2\#2 Y2)  resistor r=85.464
    Rc94  (Y2\#2 Y2\#5)  resistor r=736.0318
    Rd16  (Y2\#2 Y2\#3)  resistor r=1172.0636
    Rd29  (Y2\#3 Y2\#2314)  resistor r=86.264
    Rc79  (Y2\#4 Y2\#3)  resistor r=1036.0317
    Rc42  (Y4\#2 Y4\#3)  resistor r=2236.0317
    Rc22  (Y1\#3 Y1\#6)  resistor r=2.8325
    Rc51  (vss vss\#6)  resistor r=5.0972
    Rc1  (net7 net7\#2)  resistor r=10.1779
    Rc20  (Y1\#5 Y1\#3)  resistor r=6.2257
    Rc60  (Y1 Y1\#5)  resistor r=55.284
    Rc23  (Y1 Y1\#3)  resistor r=6.2484
    Rc66  (Y1\#8 Y1)  resistor r=80.464
    Rc29  (Y2\#2315 Y2\#2317)  resistor r=1936.0317
    Rc30  (Y2\#2315 Y2\#2314)  resistor r=85.464
    Rd30  (Y2\#2315 Y2\#2316)  resistor r=1636.0317
    Rc26  (Q\#3 Q)  resistor r=5.2
    Rd40  (vdd\#9 vdd\#2311)  resistor r=167.8m
    Rc3  (Q Q\#4)  resistor r=2.8529
    Rc57  (vss\#3 vss\#9)  resistor r=62.5645
    Rc58  (vss\#9 vss\#5)  resistor r=5.5851
    Rc15  (net4 net4\#2)  resistor r=10.1
    Rc59  (Y1\#7 Y1\#8)  resistor r=2536.0317
    Rc61  (Y1\#8 Y1\#9)  resistor r=436.0318
    Rc8  (net9 net9\#2)  resistor r=10.1779
    Rd1  (vdd\#9 vdd\#23)  resistor r=2.6224
    Rc35  (Y3\#2 Y3)  resistor r=85.464
    Rc11  (Y3\#2 Y3\#4)  resistor r=736.0318
    Rd14  (Y3\#2 Y3\#3)  resistor r=2836.0317
    Rc88  (vdd\#2 vdd\#2317)  resistor r=7.9861
    Rd31  (vdd\#2 vdd\#4)  resistor r=99.5m
    Rd10  (Y3 Y3\#2313)  resistor r=4.0799
    Rd39  (Y3 Y3\#9)  resistor r=301.5m
    Rc53  (Y4\#6 Y4\#7)  resistor r=85.464
    Rd15  (Y3\#2316 Y3\#5)  resistor r=1676.9572
    Rd13  (Y3\#2316 Y3\#2315)  resistor r=1036.0317
    Rc81  (RN\#2 RN\#3)  resistor r=1036.0317
    Rc13  (Y2 Y2\#2310)  resistor r=408.9m
    Rc73  (vdd\#2317 vdd\#4)  resistor r=3.9531
    Rc36  (Y3\#2315 Y3\#2314)  resistor r=736.0318
    Rd38  (Y3\#2315 Y3\#9)  resistor r=92.1887
    Rc40  (Y3\#2315 Y3\#2311)  resistor r=1247.4707
    Rc41  (Y3\#2311 Y3\#9)  resistor r=2.8568
    Rc37  (Y3\#9 Y3\#2312)  resistor r=2.6545
    Rc39  (Y3\#9 Y3\#2313)  resistor r=8.1598
    Rc89  (vdd\#4 vdd\#2319)  resistor r=5.3108
    Rc74  (vdd\#2319 vdd\#6)  resistor r=5.3108
    Rd44  (vdd\#4 vdd\#6)  resistor r=133.7m
    Rd43  (vdd\#4 vdd\#2318)  resistor r=2.6224
    Rc38  (Y4\#5 Y4\#6)  resistor r=1336.0317
    Rd46  (vdd\#6 vdd\#20)  resistor r=2.6224
    Rc90  (vdd\#6 vdd\#7)  resistor r=66.01m
    Rd3  (vdd\#7 vdd\#21)  resistor r=2.6224
    Rd27  (Y4\#6 Y4\#8)  resistor r=2236.0317
    Rd37  (Y3\#5 Y3\#6)  resistor r=10.1
    Rc28  (net6 net6\#2)  resistor r=10.1
    Rc34  (net12 net12\#2)  resistor r=10.1
    Rc9  (net10 net10\#2)  resistor r=10.1
    Rc65  (vss\#5 vss\#2310)  resistor r=5.0974
    Rd2  (vdd\#7 vdd\#9)  resistor r=167.8m
    Rc75  (vdd\#7 vdd\#22)  resistor r=6.6684
    Rc91  (vdd\#22 vdd\#9)  resistor r=4.4308
    Rc76  (vdd\#9 vdd\#24)  resistor r=6.6684
    Rc92  (vdd\#24 vdd\#2311)  resistor r=4.4308
    Rd42  (vdd\#2311 vdd\#25)  resistor r=2.6224
    Rc77  (vdd\#2311 vdd\#26)  resistor r=6.6684
    Rc93  (vdd\#2311 vdd\#2313)  resistor r=167.8m
    Rd49  (vdd\#26 vdd\#2313)  resistor r=4.4308
    Rd23  (Y2\#2310 Y2\#9)  resistor r=2.851
    Rc78  (vdd\#2313 vdd\#27)  resistor r=2.6224
    Rc12  (Y2\#2310 Y2\#2312)  resistor r=2.6545
    Rc80  (vdd\#2313 vdd\#28)  resistor r=7.9332
    Rd41  (vdd vdd\#2313)  resistor r=99.84m
    Rd50  (vdd vdd\#28)  resistor r=3.9666
    Rd22  (Y2\#2310 Y2\#2313)  resistor r=5.4796
    Rc87  (vdd vdd\#29)  resistor r=2.6083
    Rd33  (vdd vdd\#2315)  resistor r=2.6865
    MX44_M0_unmatched  (QN\#5 Q\#7 net5\#2 net5\#2)  nch w=2e-06 l=1e-06 \
        as=0 ad=5e-12 ps=0 pd=9e-06 sa=2e-06 sb=2e-06
    MX52_M0_unmatched  (net2 RN\#2311 vss\#1 vss\#1)  nch w=2e-06 l=1e-06 \
        as=0 ad=5e-12 ps=0 pd=9e-06 sa=2e-06 sb=2e-06
    MX51_M0_unmatched  (net1 D\#2 net2\#2 net2\#2)  nch w=2e-06 l=1e-06 as=0 \
        ad=5e-12 ps=0 pd=9e-06 sa=2e-06 sb=2e-06
    MX50_M0_unmatched  (Y4\#2315 Y3\#2316 net1\#2 net1\#2)  nch w=2e-06 \
        l=1e-06 as=0 ad=5e-12 ps=0 pd=9e-06 sa=2e-06 sb=2e-06
    MX47_M0_unmatched  (net11\#2 Y2\#21 vss\#7 vss\#7)  nch w=2e-06 \
        l=1e-06 as=0 ad=5e-12 ps=0 pd=9e-06 sa=2e-06 sb=2e-06
    MX37_M0_unmatched  (net7\#2 Y4\#3 vss\#6 vss\#6)  nch w=2e-06 l=1e-06 \
        as=0 ad=5e-12 ps=0 pd=9e-06 sa=2e-06 sb=2e-06
    MX38_M0_unmatched  (Y1\#5 Y2\#4 net7 net7)  nch w=2e-06 l=1e-06 as=0 \
        ad=5e-12 ps=0 pd=9e-06 sa=2e-06 sb=2e-06
    MX42_M0_unmatched  (net4\#2 Y2\#2316 vss\#9 vss\#9)  nch w=2e-06 \
        l=1e-06 as=0 ad=5e-12 ps=0 pd=9e-06 sa=2e-06 sb=2e-06
    MX43_M0_unmatched  (Q\#2 QN\#3 net4 net4)  nch w=2e-06 l=1e-06 as=0 \
        ad=5e-12 ps=0 pd=9e-06 sa=2e-06 sb=2e-06
    MX39_M0_unmatched  (Y2\#8 Y1\#9 net9\#2 net9\#2)  nch w=2e-06 l=1e-06 \
        as=0 ad=5e-12 ps=0 pd=9e-06 sa=2e-06 sb=2e-06
    MX46_M0_unmatched  (net6 Y3\#3 vss\#8 vss\#8)  nch w=2e-06 l=1e-06 \
        as=0 ad=5e-12 ps=0 pd=9e-06 sa=2e-06 sb=2e-06
    MX40_M0_unmatched  (net9 CK\#3 net10\#2 net10\#2)  nch w=2e-06 l=1e-06 \
        as=0 ad=5e-12 ps=0 pd=9e-06 sa=2e-06 sb=2e-06
    MX48_M0_unmatched  (net12\#2 CK\#8 net11 net11)  nch w=2e-06 l=1e-06 \
        as=0 ad=5e-12 ps=0 pd=9e-06 sa=2e-06 sb=2e-06
    MX45_M0_unmatched  (net5 RN\#7 net6\#2 net6\#2)  nch w=2e-06 l=1e-06 \
        as=0 ad=5e-12 ps=0 pd=9e-06 sa=2e-06 sb=2e-06
    MX49_M0_unmatched  (Y3\#6 Y4\#8 net12 net12)  nch w=2e-06 l=1e-06 as=0 \
        ad=5e-12 ps=0 pd=9e-06 sa=2e-06 sb=2e-06
    MX41_M0_unmatched  (net10 RN\#3 vss\#2310 vss\#2310)  nch w=2e-06 \
        l=1e-06 as=0 ad=5e-12 ps=0 pd=9e-06 sa=2e-06 sb=2e-06
ends DFFRX1
