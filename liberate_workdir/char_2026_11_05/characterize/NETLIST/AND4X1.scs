// AND4X1
simulator lang=spectre insensitive=yes
global vss vdd
subckt AND4X1 A B C D Y
    C20  (YN\#2310 vss)  capacitor c=1.92677e-18
    C24  (6 vss)  capacitor c=11.2518f
    C73  (vdd\#1 Y\#2)  capacitor c=140.489a
    C76  (vdd\#1 YN\#2310)  capacitor c=238.805a
    C100  (Y\#2 YN\#2310)  capacitor c=189.321a
    C104  (Y\#2 6)  capacitor c=850.403a
    C120  (YN\#2310 6)  capacitor c=587.847a
    C1  (C vss)  capacitor c=11.2079a
    C47  (6 C)  capacitor c=6.63089e-15
    C2  (C\#2 vss)  capacitor c=15.5516a
    C48  (C\#2 6)  capacitor c=1.81534e-15
    C4  (C\#3 vss)  capacitor c=1.12499e-19
    C50  (C\#3 6)  capacitor c=372.374a
    C5  (D vss)  capacitor c=15.349a
    C35  (D C)  capacitor c=20.5442a
    C36  (C\#3 D)  capacitor c=5.59434e-19
    C62  (6 D)  capacitor c=6.34273e-15
    C6  (D\#2 vss)  capacitor c=16.7639a
    C63  (D\#2 6)  capacitor c=2.46603e-15
    C8  (D\#3 vss)  capacitor c=3.40092e-19
    C37  (D\#3 C)  capacitor c=1.30214e-18
    C38  (D\#3 C\#3)  capacitor c=3.54583e-20
    C65  (D\#3 6)  capacitor c=356.995a
    C9  (vdd\#7 vss)  capacitor c=41.2947a
    C39  (vdd\#7 C\#2)  capacitor c=234.793a
    C10  (A vss)  capacitor c=8.01277e-18
    C92  (6 A)  capacitor c=6.51743e-15
    C11  (A\#2 vss)  capacitor c=8.51527e-18
    C93  (A\#2 6)  capacitor c=599.791a
    C13  (A\#3 vss)  capacitor c=2.34796e-19
    C95  (A\#3 6)  capacitor c=359.36a
    C14  (Y vss)  capacitor c=9.02059e-18
    C56  (Y D)  capacitor c=8.88179e-18
    C57  (D\#3 Y)  capacitor c=5.62949e-19
    C103  (6 Y)  capacitor c=2.78131e-15
    C16  (B vss)  capacitor c=1.45151e-18
    C40  (B C)  capacitor c=58.3087a
    C42  (C\#3 B)  capacitor c=3.69574e-18
    C87  (B A)  capacitor c=10.6023a
    C88  (A\#3 B)  capacitor c=6.72e-19
    C110  (6 B)  capacitor c=978.273a
    C17  (B\#4 vss)  capacitor c=12.2271a
    C111  (B\#4 6)  capacitor c=1.81549e-15
    C18  (B\#3 vss)  capacitor c=67.1792a
    C112  (B\#3 6)  capacitor c=2.0796e-15
    C19  (B\#2 vss)  capacitor c=17.0509a
    C41  (B\#2 C)  capacitor c=25.8323a
    C43  (C\#3 B\#2)  capacitor c=1.63731e-18
    C113  (B\#2 6)  capacitor c=5.8164e-15
    C23  (YN\#4 vss)  capacitor c=48.8487a
    C107  (YN\#4 B)  capacitor c=19.8732a
    C108  (YN\#4 B\#4)  capacitor c=841.707a
    C109  (YN\#4 B\#2)  capacitor c=7.25281e-19
    C118  (B\#2 net3\#2)  capacitor c=1.21532e-18
    C31  (net3\#2 vss)  capacitor c=74.1524a
    C116  (net3\#2 B)  capacitor c=2.7505e-18
    C114  (net4 B)  capacitor c=2.9388e-18
    C27  (net4 vss)  capacitor c=74.1313a
    C115  (B\#3 net4)  capacitor c=83.616a
    C117  (net3\#2 B\#3)  capacitor c=83.616a
    C131  (net4 6)  capacitor c=237.766a
    C134  (net3\#2 6)  capacitor c=366.89a
    C137  (net3\#2 net4)  capacitor c=39.8112a
    C28  (net4\#2 vss)  capacitor c=66.4358a
    C30  (net3 vss)  capacitor c=63.7518a
    C51  (net3 C)  capacitor c=9.12576e-18
    C44  (YN\#2 C)  capacitor c=51.7865a
    C45  (YN\#2 C\#2)  capacitor c=746.262a
    C46  (YN\#2 C\#3)  capacitor c=3.28235e-18
    C49  (C\#4 6)  capacitor c=2.16231e-15
    C52  (C\#4 net3)  capacitor c=83.616a
    C61  (YN\#2 D\#2)  capacitor c=868.45a
    C122  (YN\#2 6)  capacitor c=17.0018f
    C132  (net4\#2 6)  capacitor c=238.004a
    C133  (net3 6)  capacitor c=237.178a
    C3  (vss\#1 C\#4)  capacitor c=80.641a
    C25  (vss\#1 6)  capacitor c=12.6505f
    C7  (vss\#1 D\#4)  capacitor c=75.8965a
    C64  (D\#4 6)  capacitor c=1.46412e-15
    C15  (vss\#1 Y\#1)  capacitor c=109.192a
    C105  (Y\#1 6)  capacitor c=1.87602e-15
    C98  (YN Y)  capacitor c=408.94a
    C75  (vdd\#1 YN)  capacitor c=30.4104a
    C99  (Y\#2 YN)  capacitor c=101.64a
    C106  (Y\#2 X9_5)  capacitor c=406.72a
    C82  (vdd\#1 X9_5)  capacitor c=212.366a
    C126  (YN\#2310 X9_5)  capacitor c=508.173a
    C81  (vdd\#2 6)  capacitor c=23.9562f
    C21  (vss\#1 YN\#2312)  capacitor c=187.483a
    C101  (Y\#1 YN\#2312)  capacitor c=372.885a
    C121  (YN\#2312 6)  capacitor c=3.4178e-15
    C102  (YN\#6 Y\#1)  capacitor c=22.809a
    C123  (YN\#2312 net2)  capacitor c=1.12473e-18
    C22  (YN\#6 vss\#1)  capacitor c=91.0597a
    C32  (vss\#1 net2)  capacitor c=72.6356a
    C34  (net2\#2 vss\#1)  capacitor c=72.6564a
    C33  (net2\#2 vss)  capacitor c=1.49571e-18
    C26  (vss\#2 6)  capacitor c=3.93e-16
    C29  (vss\#2 net4\#2)  capacitor c=39.1322a
    C53  (net2\#2 C\#4)  capacitor c=83.616a
    C138  (net2\#2 net3)  capacitor c=39.8112a
    C58  (YN\#6 D)  capacitor c=531.598a
    C66  (net2 D)  capacitor c=46.786a
    C59  (YN\#6 D\#4)  capacitor c=167.909a
    C60  (D\#3 YN\#6)  capacitor c=30.4761a
    C68  (D\#3 net2)  capacitor c=1.09427e-19
    C67  (D\#4 net2)  capacitor c=83.616a
    C124  (YN\#6 net2)  capacitor c=46.0379a
    C125  (YN\#2 net2\#2)  capacitor c=1.56407e-18
    C135  (net2 6)  capacitor c=236.848a
    C136  (net2\#2 6)  capacitor c=238.004a
    C94  (A\#4 6)  capacitor c=3.47585e-15
    C12  (vss\#2 A\#4)  capacitor c=187.972a
    C96  (net4\#2 A\#4)  capacitor c=83.616a
    C54  (C\#2 X7_5)  capacitor c=531.824a
    C78  (vdd\#7 YN\#8)  capacitor c=204.098a
    C84  (vdd\#7 X7_5)  capacitor c=148.996a
    C128  (YN\#8 X7_5)  capacitor c=148.996a
    C55  (vdd\#6 D\#2)  capacitor c=234.793a
    C77  (vdd\#6 YN\#7)  capacitor c=202.322a
    C69  (D\#2 X8_5)  capacitor c=531.824a
    C83  (vdd\#6 X8_5)  capacitor c=148.996a
    C127  (YN\#7 X8_5)  capacitor c=148.996a
    C70  (vdd\#5 A)  capacitor c=21.508a
    C89  (YN\#5 A)  capacitor c=206.03a
    C71  (vdd\#5 A\#2)  capacitor c=238.688a
    C72  (A\#3 vdd\#5)  capacitor c=1.36323e-18
    C91  (A\#3 YN\#5)  capacitor c=13.0587a
    C80  (vdd\#5 YN\#5)  capacitor c=178.905a
    C90  (YN\#5 A\#2)  capacitor c=189.689a
    C97  (A\#2 X5_5)  capacitor c=531.582a
    C130  (YN\#5 X5_5)  capacitor c=181.705a
    C86  (vdd\#5 X5_5)  capacitor c=437.382a
    C74  (vdd\#8 B\#4)  capacitor c=234.793a
    C79  (vdd\#8 YN\#9)  capacitor c=204.107a
    C85  (vdd\#8 X6_5)  capacitor c=148.996a
    C119  (B\#4 X6_5)  capacitor c=531.824a
    C129  (YN\#9 X6_5)  capacitor c=148.996a
    MX9_M0_unmatched  (Y\#2 YN\#2310 vdd\#1 vdd\#1)  pch w=4e-06 l=1e-06 \
        as=0 ad=1e-11 ps=0 pd=1.3e-05 sa=2e-06 sb=2e-06
    MX7_M0_unmatched  (YN\#8 C\#2 vdd\#7 vdd\#7)  pch w=4e-06 l=1e-06 as=0 \
        ad=1e-11 ps=0 pd=1.3e-05 sa=2e-06 sb=2e-06
    MX8_M0_unmatched  (YN\#7 D\#2 vdd\#6 vdd\#6)  pch w=4e-06 l=1e-06 as=0 \
        ad=1e-11 ps=0 pd=1.3e-05 sa=2e-06 sb=2e-06
    MX5_M0_unmatched  (YN\#5 A\#2 vdd\#5 vdd\#5)  pch w=4e-06 l=1e-06 as=0 \
        ad=1e-11 ps=0 pd=1.3e-05 sa=2e-06 sb=2e-06
    MX6_M0_unmatched  (YN\#9 B\#4 vdd\#8 vdd\#8)  pch w=4e-06 l=1e-06 as=0 \
        ad=1e-11 ps=0 pd=1.3e-05 sa=2e-06 sb=2e-06
    Rc24  (vdd vdd\#5)  resistor r=2.6222
    Rc21  (vdd vdd\#4)  resistor r=66.34m
    Rs1  (6 vss)  resistor r=50
    Rd13  (C\#2 C\#3)  resistor r=1936.0317
    Rd15  (C\#3 C)  resistor r=85.564
    Rc13  (D\#2 D\#3)  resistor r=2536.0317
    Rc12  (D\#3 D)  resistor r=85.564
    Rd7  (A\#2 A\#3)  resistor r=736.0318
    Rd9  (A\#3 A)  resistor r=85.564
    Rc17  (Y Y\#2)  resistor r=2.775
    Rd8  (B\#2 B\#3)  resistor r=1636.0317
    Rc9  (B\#2 B\#4)  resistor r=1936.0317
    Rc15  (B\#2 B)  resistor r=85.564
    Rc5  (net3 net3\#2)  resistor r=10.1
    Rc2  (net4 net4\#2)  resistor r=10.1
    Rc8  (C\#3 C\#4)  resistor r=1636.0317
    Rc18  (YN\#2 YN\#4)  resistor r=401.4m
    Rc26  (vss\#1 vss)  resistor r=5.3715
    Rd14  (D\#3 D\#4)  resistor r=1036.0317
    Rc16  (Y Y\#1)  resistor r=5.4
    Rd10  (YN\#2310 YN\#2311)  resistor r=736.0318
    Rd6  (vdd\#1 vdd\#2)  resistor r=2.6962
    Rd12  (YN\#2311 YN)  resistor r=80.464
    Rc10  (YN YN\#2)  resistor r=5.093
    Rc11  (YN\#2311 YN\#2312)  resistor r=2836.0317
    Rd5  (vdd\#2 vdd\#7)  resistor r=5.3108
    Rc27  (vss vss\#2)  resistor r=5.0972
    Rc22  (YN\#2 YN\#6)  resistor r=5.493
    Rc7  (net2 net2\#2)  resistor r=10.1
    Rc14  (A\#3 A\#4)  resistor r=2836.0317
    Rc25  (vdd\#7 vdd\#4)  resistor r=5.3108
    Rd1  (YN\#2 YN\#8)  resistor r=5.4316
    Rd3  (YN\#8 YN\#4)  resistor r=5.5757
    Rd11  (YN\#2 YN\#7)  resistor r=2.668
    Rd4  (vdd\#2 vdd\#4)  resistor r=133.7m
    Rc19  (vdd\#2 vdd\#6)  resistor r=2.6224
    Rd2  (YN\#4 YN\#5)  resistor r=2.851
    Rc23  (YN\#4 YN\#9)  resistor r=2.6545
    Rc20  (vdd\#4 vdd\#8)  resistor r=2.6224
    MX11_M0_unmatched  (net3\#2 B\#3 net4 net4)  nch w=2e-06 l=1e-06 as=0 \
        ad=5e-12 ps=0 pd=9e-06 sa=2e-06 sb=2e-06
    MX14_M0_unmatched  (Y\#1 YN\#2312 vss\#1 vss\#1)  nch w=2e-06 l=1e-06 \
        as=0 ad=5e-12 ps=0 pd=9e-06 sa=2e-06 sb=2e-06
    MX12_M0_unmatched  (net2\#2 C\#4 net3 net3)  nch w=2e-06 l=1e-06 as=0 \
        ad=5e-12 ps=0 pd=9e-06 sa=2e-06 sb=2e-06
    MX13_M0_unmatched  (YN\#6 D\#4 net2 net2)  nch w=2e-06 l=1e-06 as=0 \
        ad=5e-12 ps=0 pd=9e-06 sa=2e-06 sb=2e-06
    MX10_M0_unmatched  (net4\#2 A\#4 vss\#2 vss\#2)  nch w=2e-06 l=1e-06 \
        as=0 ad=5e-12 ps=0 pd=9e-06 sa=2e-06 sb=2e-06
ends AND4X1
