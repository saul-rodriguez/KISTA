// NAND4X1
simulator lang=spectre insensitive=yes
global vss vdd
subckt NAND4X1 C D Y A B
    C2  (vdd\#1 D\#2)  capacitor c=235.866a
    C3  (vdd\#1 Y\#6)  capacitor c=169.244a
    C45  (D\#2 vss)  capacitor c=6.06615e-18
    C49  (D\#2 5)  capacitor c=2.45402e-15
    C87  (5 vss)  capacitor c=18.9538f
    C10  (vdd\#5 vss)  capacitor c=29.1464a
    C1  (vdd\#5 C\#2)  capacitor c=234.793a
    C25  (C\#2 vss)  capacitor c=15.6154a
    C33  (C\#2 5)  capacitor c=1.81534e-15
    C4  (vdd\#5 Y\#7)  capacitor c=201.224a
    C12  (vdd\#2 5)  capacitor c=19.3813f
    C13  (vdd\#1 X7_5)  capacitor c=181.705a
    C55  (D\#2 X7_5)  capacitor c=508.173a
    C66  (Y\#6 X7_5)  capacitor c=406.72a
    C14  (vdd\#5 X6_5)  capacitor c=148.996a
    C39  (C\#2 X6_5)  capacitor c=531.824a
    C67  (Y\#7 X6_5)  capacitor c=148.996a
    C22  (Y\#2 C\#2)  capacitor c=746.262a
    C23  (Y\#2 C\#3)  capacitor c=3.31278e-18
    C27  (C\#3 vss)  capacitor c=1.00755e-19
    C35  (C\#3 5)  capacitor c=371.173a
    C63  (Y\#2 5)  capacitor c=12.0193f
    C41  (D\#2 Y)  capacitor c=869.534a
    C20  (D\#3 C\#3)  capacitor c=3.54303e-20
    C43  (D\#3 Y)  capacitor c=30.5012a
    C47  (D\#3 vss)  capacitor c=4.1944e-19
    C51  (D\#3 5)  capacitor c=356.998a
    C18  (C\#3 D)  capacitor c=5.58993e-19
    C40  (Y D)  capacitor c=531.992a
    C44  (vss D)  capacitor c=15.7885a
    C48  (5 D)  capacitor c=6.34278e-15
    C59  (Y\#5 vss)  capacitor c=111.524a
    C17  (D C)  capacitor c=20.5372a
    C52  (net2 D)  capacitor c=46.786a
    C19  (D\#3 C)  capacitor c=1.3017e-18
    C21  (Y\#2 C)  capacitor c=52.2666a
    C24  (vss C)  capacitor c=11.036a
    C32  (5 C)  capacitor c=6.61196e-15
    C54  (D\#3 net2)  capacitor c=1.09427e-19
    C42  (Y\#5 D\#4)  capacitor c=168.949a
    C46  (D\#4 vss)  capacitor c=67.4808a
    C50  (D\#4 5)  capacitor c=1.42516e-15
    C53  (D\#4 net2)  capacitor c=83.616a
    C64  (Y\#5 net2)  capacitor c=46.0379a
    C94  (net2 vss)  capacitor c=73.0066a
    C110  (net2 5)  capacitor c=236.848a
    C65  (Y\#2 net2\#2)  capacitor c=1.56407e-18
    C95  (net2\#2 vss)  capacitor c=73.7811a
    C111  (net2\#2 5)  capacitor c=238.004a
    C26  (C\#4 vss)  capacitor c=80.4468a
    C34  (C\#4 5)  capacitor c=2.16246e-15
    C38  (net2\#2 C\#4)  capacitor c=83.616a
    C28  (B C)  capacitor c=58.3087a
    C30  (C\#3 B)  capacitor c=3.69574e-18
    C31  (C\#3 B\#2)  capacitor c=1.63731e-18
    C29  (B\#2 C)  capacitor c=25.8323a
    C36  (net3 C)  capacitor c=9.12576e-18
    C37  (C\#4 net3)  capacitor c=83.616a
    C113  (net2\#2 net3)  capacitor c=39.8112a
    C60  (Y\#2 B)  capacitor c=19.8732a
    C62  (Y\#2 B\#2)  capacitor c=7.25281e-19
    C83  (B vss)  capacitor c=1.45151e-18
    C86  (B\#2 vss)  capacitor c=17.0874a
    C92  (net3 vss)  capacitor c=74.1313a
    C96  (5 B)  capacitor c=978.273a
    C99  (B\#2 5)  capacitor c=5.81638e-15
    C108  (net3 5)  capacitor c=237.178a
    C93  (net3\#2 vss)  capacitor c=74.1524a
    C102  (net3\#2 B)  capacitor c=2.7505e-18
    C104  (B\#2 net3\#2)  capacitor c=1.21532e-18
    C109  (net3\#2 5)  capacitor c=366.89a
    C61  (Y\#2 B\#4)  capacitor c=841.707a
    C84  (B\#4 vss)  capacitor c=12.2332a
    C97  (B\#4 5)  capacitor c=1.81549e-15
    C85  (B\#3 vss)  capacitor c=66.6751a
    C98  (B\#3 5)  capacitor c=2.07934e-15
    C103  (net3\#2 B\#3)  capacitor c=83.616a
    C11  (vdd\#6 B\#4)  capacitor c=234.793a
    C5  (vdd\#6 Y\#8)  capacitor c=204.107a
    C6  (vdd\#4 Y\#4)  capacitor c=178.905a
    C15  (vdd\#6 X5_5)  capacitor c=148.996a
    C68  (Y\#8 X5_5)  capacitor c=148.996a
    C105  (B\#4 X5_5)  capacitor c=531.824a
    C7  (vdd\#4 A)  capacitor c=21.508a
    C56  (Y\#4 A)  capacitor c=206.03a
    C70  (vss A)  capacitor c=5.89847e-18
    C75  (B A)  capacitor c=10.6023a
    C77  (5 A)  capacitor c=6.51741e-15
    C8  (vdd\#4 A\#2)  capacitor c=238.688a
    C57  (Y\#4 A\#2)  capacitor c=189.689a
    C71  (A\#2 vss)  capacitor c=8.51527e-18
    C78  (A\#2 5)  capacitor c=599.791a
    C9  (A\#3 vdd\#4)  capacitor c=1.36323e-18
    C16  (vdd\#4 X4_5)  capacitor c=437.382a
    C58  (A\#3 Y\#4)  capacitor c=13.0587a
    C69  (Y\#4 X4_5)  capacitor c=181.705a
    C82  (A\#2 X4_5)  capacitor c=531.582a
    C74  (A\#3 vss)  capacitor c=1.92715e-19
    C76  (A\#3 B)  capacitor c=6.72e-19
    C100  (net4 B)  capacitor c=2.9388e-18
    C80  (A\#3 5)  capacitor c=359.359a
    C89  (net4 vss)  capacitor c=74.1313a
    C101  (B\#3 net4)  capacitor c=83.616a
    C112  (net3\#2 net4)  capacitor c=39.8112a
    C106  (net4 5)  capacitor c=237.766a
    C90  (net4\#2 vss)  capacitor c=66.4358a
    C72  (vss\#1 A)  capacitor c=2.20122e-18
    C73  (vss\#1 A\#4)  capacitor c=170.544a
    C79  (A\#4 5)  capacitor c=3.47533e-15
    C81  (net4\#2 A\#4)  capacitor c=83.616a
    C88  (vss\#1 5)  capacitor c=392.727a
    C91  (vss\#1 net4\#2)  capacitor c=39.1322a
    C107  (net4\#2 5)  capacitor c=238.004a
    MX11_M0_unmatched  (Y\#5 D\#4 net2 net2)  nch w=2e-06 l=1e-06 as=0 \
        ad=5e-12 ps=0 pd=9e-06 sa=2e-06 sb=2e-06
    MX10_M0_unmatched  (net2\#2 C\#4 net3 net3)  nch w=2e-06 l=1e-06 as=0 \
        ad=5e-12 ps=0 pd=9e-06 sa=2e-06 sb=2e-06
    MX9_M0_unmatched  (net3\#2 B\#3 net4 net4)  nch w=2e-06 l=1e-06 as=0 \
        ad=5e-12 ps=0 pd=9e-06 sa=2e-06 sb=2e-06
    MX8_M0_unmatched  (net4\#2 A\#4 vss\#1 vss\#1)  nch w=2e-06 l=1e-06 \
        as=0 ad=5e-12 ps=0 pd=9e-06 sa=2e-06 sb=2e-06
    Rs1  (5 vss)  resistor r=50
    Rd4  (vdd\#2 vdd\#1)  resistor r=2.6962
    Rc18  (vdd\#2 vdd\#5)  resistor r=2.6224
    Rd2  (Y\#2 Y\#7)  resistor r=2.6545
    Rd7  (C\#2 C\#3)  resistor r=1936.0317
    Rc10  (Y\#6 Y\#2)  resistor r=7.6916
    Rc11  (Y Y\#6)  resistor r=4.2472
    Rc8  (D\#2 D\#3)  resistor r=2536.0317
    Rd3  (Y Y\#2)  resistor r=282.2m
    Rd1  (Y Y\#5)  resistor r=5.4
    Rc13  (D\#3 D)  resistor r=85.564
    Rd8  (D\#3 D\#4)  resistor r=1036.0317
    Rc7  (net2 net2\#2)  resistor r=10.1
    Rd9  (C\#3 C)  resistor r=85.564
    Rc12  (C\#3 C\#4)  resistor r=1636.0317
    Rc5  (net3 net3\#2)  resistor r=10.1
    Rc15  (B\#2 B)  resistor r=85.564
    Rc9  (B\#2 B\#4)  resistor r=1936.0317
    Rd11  (B\#2 B\#3)  resistor r=1636.0317
    Rc21  (vdd\#2 vdd\#6)  resistor r=5.2977
    Rc20  (vdd vdd\#2)  resistor r=0.134
    Rc17  (vdd vdd\#6)  resistor r=5.3242
    Rd5  (vdd vdd\#4)  resistor r=2.6222
    Rc19  (Y\#2 Y\#8)  resistor r=3.0334
    Rd6  (Y\#2 Y\#4)  resistor r=3.2579
    Rc16  (Y\#8 Y\#4)  resistor r=44.0848
    Rd10  (A\#2 A\#3)  resistor r=736.0318
    Rc2  (net4 net4\#2)  resistor r=10.1
    Rc22  (vss\#1 vss)  resistor r=5.0837
    Rd12  (A\#3 A)  resistor r=85.564
    Rc14  (A\#3 A\#4)  resistor r=2836.0317
    MX7_M0_unmatched  (Y\#6 D\#2 vdd\#1 vdd\#1)  pch w=4e-06 l=1e-06 as=0 \
        ad=1e-11 ps=0 pd=1.3e-05 sa=2e-06 sb=2e-06
    MX6_M0_unmatched  (Y\#7 C\#2 vdd\#5 vdd\#5)  pch w=4e-06 l=1e-06 as=0 \
        ad=1e-11 ps=0 pd=1.3e-05 sa=2e-06 sb=2e-06
    MX5_M0_unmatched  (Y\#8 B\#4 vdd\#6 vdd\#6)  pch w=4e-06 l=1e-06 as=0 \
        ad=1e-11 ps=0 pd=1.3e-05 sa=2e-06 sb=2e-06
    MX4_M0_unmatched  (Y\#4 A\#2 vdd\#4 vdd\#4)  pch w=4e-06 l=1e-06 as=0 \
        ad=1e-11 ps=0 pd=1.3e-05 sa=2e-06 sb=2e-06
ends NAND4X1
