// ADDFX1
simulator lang=spectre insensitive=yes
global vss vdd
subckt ADDFX1 A B CIN COUT SUM
    Rc80  (coutn\#2314 coutn\#2315)  resistor r=300
    Rc81  (coutn\#2315 coutn\#2310)  resistor r=436.0318
    Rd22  (CIN\#6 CIN\#4)  resistor r=6.5871
    Rs1  (7 vss)  resistor r=50
    Rc54  (sumn\#5 sumn\#8)  resistor r=2.668
    Rc52  (sumn\#2310 sumn\#2311)  resistor r=736.0318
    Rc50  (sumn\#2311 sumn\#5)  resistor r=85.557
    Rc71  (vdd\#5 vdd\#9)  resistor r=2.7345
    Rd25  (coutn coutn\#2310)  resistor r=85.764
    Rc70  (vdd\#5 vdd\#2311)  resistor r=2.9839
    Rc51  (vdd\#9 vdd\#2311)  resistor r=60.9516
    Rd8  (coutn coutn\#9)  resistor r=2.6741
    Rc22  (net38 net38\#2)  resistor r=22.075
    Rc26  (net38 net38\#5)  resistor r=3.532
    Rc23  (net38\#2 net38\#5)  resistor r=3.2704
    Rd38  (vdd\#1 vdd\#2)  resistor r=2.8705
    Rc61  (SUM SUM\#2)  resistor r=2.675
    Rc49  (sumn\#2311 sumn\#2312)  resistor r=2836.0317
    Rc30  (CIN\#2310 CIN\#2311)  resistor r=1336.0317
    Rc60  (SUM SUM\#1)  resistor r=5.5
    Rc47  (net39 net39\#2)  resistor r=5.1779
    Rd17  (CIN\#4 CIN\#2311)  resistor r=113.3832
    Rc89  (CIN\#6 CIN\#2311)  resistor r=377.9439
    Rc46  (net43 net43\#2)  resistor r=5.2
    Rd13  (B\#2311 B\#9)  resistor r=32.1385
    Rd21  (B\#9 B\#7)  resistor r=7.4607
    Rc78  (B\#2311 B\#7)  resistor r=8.356
    Rd1  (CIN\#4 CIN)  resistor r=0.1
    Rc84  (B\#7 B)  resistor r=0.1
    Rc31  (CIN\#2 CIN)  resistor r=0.1
    Rd7  (coutn coutn\#8)  resistor r=2.8404
    Rc76  (coutn\#9 coutn\#8)  resistor r=102.4616
    Rd11  (CIN\#6 CIN\#7)  resistor r=1583.8093
    Rc63  (vdd\#2 vdd\#6)  resistor r=2.5488
    Rc59  (net47 net47\#2)  resistor r=38.95
    Rc55  (net47\#2 net47\#5)  resistor r=2.8852
    Rc43  (A\#2312 A\#2315)  resistor r=2783.8093
    Rc33  (net47 net47\#5)  resistor r=3.116
    Rd14  (B\#2311 B\#2314)  resistor r=2183.8093
    Rc79  (B\#9 B\#2310)  resistor r=2183.8093
    Rd15  (vdd\#2 vdd\#7)  resistor r=5.1621
    Rc69  (vdd\#2 vdd\#4)  resistor r=130.8m
    Rc64  (vdd\#7 vdd\#4)  resistor r=5.1621
    Rc73  (vdd\#4 vdd\#5)  resistor r=223.6m
    Rc65  (vdd vdd\#5)  resistor r=366.3m
    Rd31  (coutn\#2313 coutn\#2314)  resistor r=3017.6187
    Rd24  (coutn\#2311 coutn\#2310)  resistor r=2836.0317
    Rc56  (sumn\#5 sumn\#9)  resistor r=38.1791
    Rc68  (vdd vdd\#2312)  resistor r=2.8002
    Rc27  (net38\#5 net38\#4)  resistor r=2.5
    Rc25  (net38\#5 net38\#6)  resistor r=2.7
    Rc37  (net47\#5 net47\#4)  resistor r=2.5
    Rc19  (sumn sumn\#5)  resistor r=1.4378
    Rc58  (sumn\#5 sumn\#7)  resistor r=5.493
    Rc57  (sumn sumn\#9)  resistor r=2.9005
    Rc66  (vdd\#4 vdd\#8)  resistor r=2.5488
    Rc34  (net47\#5 net47\#8)  resistor r=3.0755
    Rc38  (net47\#5 net47\#6)  resistor r=2.8878
    Rc53  (sumn sumn\#3)  resistor r=1150.953
    Rc39  (net47\#6 net47\#8)  resistor r=38.4437
    Rd34  (A\#2310 A\#2311)  resistor r=2783.8093
    Rc40  (A\#2312 A\#2310)  resistor r=53.6769
    Rc74  (coutn\#2313 coutn\#2312)  resistor r=2700
    Rd30  (coutn\#2312 coutn\#2311)  resistor r=3317.6187
    Rd35  (A\#6 A\#8)  resistor r=2756.5518
    Rc87  (CIN\#3 CIN\#4)  resistor r=1653.2665
    Rc4  (net37 net37\#2)  resistor r=5.2
    Rd18  (CIN\#1 CIN\#2)  resistor r=2253.2666
    Rc88  (B\#6 B\#7)  resistor r=1653.2665
    Rd39  (A\#2 A)  resistor r=83.7573
    Rd23  (CIN\#2311 CIN\#2312)  resistor r=2236.0317
    Rc86  (CIN\#6 CIN\#5)  resistor r=2242.8401
    Rc14  (vss\#1 vss\#2)  resistor r=5.2712
    Rc48  (net5 net5\#2)  resistor r=10.1
    Rd12  (B\#9 B\#8)  resistor r=1642.84
    Rc5  (vss\#2 vss\#8)  resistor r=10.2608
    Rd5  (A\#2312 A\#2314)  resistor r=1042.8398
    Rc41  (A\#2 A\#4)  resistor r=956.5518
    Rd6  (coutn coutn\#5)  resistor r=2342.9441
    Rc75  (coutn coutn\#3)  resistor r=2252.8311
    Rc82  (coutn\#3 coutn\#5)  resistor r=10.2227
    Rd28  (vss vss\#2316)  resistor r=5.7614
    Rc7  (vss\#8 vss\#4)  resistor r=10.2608
    Rc77  (B\#2311 B\#2313)  resistor r=1642.84
    Rd36  (A\#1 A\#2)  resistor r=2141.092
    Rd19  (B\#3 B)  resistor r=123.364
    Rd20  (B\#2 B\#3)  resistor r=2244.8411
    Rc83  (B\#1 B\#2)  resistor r=600
    Rd33  (COUT\#3 COUT\#4)  resistor r=96701.1562
    Rc28  (COUT\#3 COUT)  resistor r=1934.0231
    Rd37  (A\#2312 A\#5)  resistor r=6.978
    Rc85  (B\#3 B\#4)  resistor r=1644.8412
    Rc42  (vss vss\#2314)  resistor r=5.5398
    Rd10  (vss\#2316 vss\#2314)  resistor r=104.6865
    Rc45  (net9 net9\#2)  resistor r=10.2
    Rd26  (vss\#2 vss\#7)  resistor r=5.0974
    Rd9  (vss\#2 vss\#4)  resistor r=132.9m
    Rd3  (vss\#4 vss\#6)  resistor r=301.7m
    Rd4  (vss\#6 vss)  resistor r=366.3m
    Rc20  (net20\#5 net20\#6)  resistor r=5.2
    Rd29  (vss\#6 vss\#2313)  resistor r=5.4781
    Rc67  (A\#5 A)  resistor r=0.55
    Rd27  (net3\#2 net3\#4)  resistor r=15.2
    Rd32  (net3 net3\#2)  resistor r=15.2
    Rc29  (net3 net3\#4)  resistor r=15.808
    Rc8  (net1 net1\#2)  resistor r=10.2
    Rc17  (vss\#6 vss\#2311)  resistor r=5.1896
    Rc16  (vss\#2311 vss\#2313)  resistor r=281.2561
    Rc15  (vss\#2310 vss\#6)  resistor r=23.2984
    Rc32  (COUT COUT\#4)  resistor r=5.1003
    Rc6  (vss\#4 vss\#2310)  resistor r=6.6095
    Rd2  (vss\#4 vss\#9)  resistor r=5.0974
    Rc35  (net20\#2 net20\#5)  resistor r=5.3923
    Rc36  (net20 net20\#2)  resistor r=140.2
    Rc18  (net20 net20\#5)  resistor r=5.608
    Rc21  (net20\#5 net20\#4)  resistor r=5
    Rc72  (A\#6 A\#7)  resistor r=1115.8707
    Rd16  (A\#6 A\#5)  resistor r=83.4573
    Rc62  (A\#2310 A\#5)  resistor r=6.2304
    Rc44  (A\#2310 A\#9)  resistor r=1042.8398
    C111  (net9\#2 CIN\#5)  capacitor c=2.70201e-18
    C180  (net9\#2 B\#2311)  capacitor c=23.4863a
    C7  (vdd\#1 SUM\#2)  capacitor c=140.489a
    C16  (vdd\#1 sumn\#2310)  capacitor c=239.208a
    C18  (sumn\#5 vdd\#1)  capacitor c=28.6001a
    C62  (CIN\#6 vss)  capacitor c=7.79155e-18
    C63  (CIN\#4 vss)  capacitor c=12.0625a
    C93  (sumn\#5 CIN\#4)  capacitor c=897.75a
    C102  (CIN\#6 7)  capacitor c=13.9787f
    C103  (CIN\#4 7)  capacitor c=13.5897f
    C197  (SUM\#2 vss)  capacitor c=4.9094e-18
    C225  (sumn\#2310 vss)  capacitor c=7.12066e-20
    C261  (SUM\#2 sumn\#2310)  capacitor c=189.321a
    C265  (sumn\#5 SUM\#2)  capacitor c=21.9918a
    C268  (SUM\#2 7)  capacitor c=397.718a
    C345  (sumn\#2310 7)  capacitor c=587.831a
    C347  (sumn\#5 7)  capacitor c=31.7631f
    C1  (vdd\#1 CIN\#2310)  capacitor c=70.3459a
    C58  (CIN\#2310 vss)  capacitor c=7.98513e-18
    C96  (CIN\#2310 7)  capacitor c=1.23115e-15
    C5  (vdd\#5 vss)  capacitor c=82.8551a
    C21  (vdd\#5 7)  capacitor c=73.8853f
    C6  (vdd\#5 COUT\#3)  capacitor c=241.581a
    C68  (COUT\#3 CIN\#4)  capacitor c=1.06615e-15
    C194  (COUT\#3 vss)  capacitor c=37.2264a
    C257  (COUT\#3 7)  capacitor c=75.0889a
    C15  (vdd\#5 coutn\#2314)  capacitor c=983.56a
    C218  (coutn\#2314 vss)  capacitor c=6.22162e-18
    C252  (COUT\#3 coutn\#2314)  capacitor c=214.094a
    C321  (coutn\#2314 7)  capacitor c=2.91194e-15
    C17  (sumn\#8 vdd\#1)  capacitor c=109.857a
    C91  (sumn\#8 CIN\#2310)  capacitor c=239.641a
    C19  (sumn\#2311 vdd\#1)  capacitor c=1.81026e-18
    C228  (sumn\#2311 vss)  capacitor c=3.47833e-19
    C348  (sumn\#2311 7)  capacitor c=343.358a
    C26  (vdd\#5 net38)  capacitor c=125.051a
    C242  (net38 vss)  capacitor c=13.6852a
    C22  (vdd\#9 net38)  capacitor c=25.8973a
    C11  (vdd\#9 coutn)  capacitor c=288.12a
    C85  (CIN\#4 coutn)  capacitor c=2.66198e-15
    C216  (coutn vss)  capacitor c=83.4904a
    C251  (COUT\#3 coutn)  capacitor c=17.3317a
    C319  (7 coutn)  capacitor c=19.2696f
    C333  (net38 coutn)  capacitor c=5.69258e-18
    C13  (coutn\#2310 vdd\#9)  capacitor c=14.6018a
    C89  (coutn\#2310 CIN\#4)  capacitor c=45.6829a
    C221  (coutn\#2310 vss)  capacitor c=6.13314e-19
    C253  (coutn\#2310 COUT\#3)  capacitor c=1.14161e-18
    C328  (coutn\#2310 7)  capacitor c=424.774a
    C23  (vdd\#2311 net38)  capacitor c=84.6238a
    C42  (vdd\#9 X40_5)  capacitor c=367.496a
    C260  (COUT\#3 X40_5)  capacitor c=301.865a
    C338  (X40_5 coutn)  capacitor c=243.579a
    C339  (coutn\#2314 X40_5)  capacitor c=261.718a
    C340  (coutn\#2310 X40_5)  capacitor c=16.044a
    C9  (vdd\#2311 A\#8)  capacitor c=694.926a
    C202  (A\#8 vss)  capacitor c=9.29154e-18
    C271  (A\#8 coutn)  capacitor c=543.55a
    C277  (coutn\#2310 A\#8)  capacitor c=35.8025a
    C285  (A\#8 7)  capacitor c=2.92893e-15
    C306  (A\#8 net38)  capacitor c=171.272a
    C12  (coutn\#9 vdd\#2311)  capacitor c=20.1566a
    C43  (vdd\#2311 X39_5)  capacitor c=161.018a
    C314  (A\#8 X39_5)  capacitor c=528.653a
    C324  (coutn\#9 7)  capacitor c=79.2399a
    C341  (coutn\#9 X39_5)  capacitor c=45.3289a
    C389  (X39_5 net38)  capacitor c=152.718a
    C27  (vdd\#5 net38\#2)  capacitor c=204.923a
    C334  (net38\#2 coutn\#9)  capacitor c=114.151a
    C36  (vdd\#1 net39)  capacitor c=72.8517a
    C121  (CIN\#2310 net39)  capacitor c=198.473a
    C122  (CIN\#6 net39)  capacitor c=5.26537e-19
    C123  (CIN\#4 net39)  capacitor c=1.78571e-18
    C246  (net39 vss)  capacitor c=3.78247e-18
    C360  (sumn\#2310 net39)  capacitor c=1.96616e-18
    C363  (sumn\#2310 X48_5)  capacitor c=508.154a
    C37  (vdd\#1 X48_5)  capacitor c=216.669a
    C270  (SUM\#2 X48_5)  capacitor c=406.72a
    C69  (CIN\#6 SUM)  capacitor c=1.31569e-18
    C70  (CIN\#4 SUM)  capacitor c=4.46208e-18
    C264  (sumn\#5 SUM)  capacitor c=444.762a
    C266  (sumn\#2311 SUM)  capacitor c=28.3946a
    C267  (7 SUM)  capacitor c=2.7654e-15
    C346  (sumn\#2312 7)  capacitor c=3.41784e-15
    C361  (sumn\#8 net39)  capacitor c=152.184a
    C382  (net39 7)  capacitor c=433.413a
    C364  (sumn\#8 X47_5)  capacitor c=149.036a
    C125  (CIN\#2310 X47_5)  capacitor c=534.803a
    C405  (X47_5 net39)  capacitor c=194.872a
    C67  (CIN\#2311 vss)  capacitor c=3.64765e-19
    C72  (CIN\#2311 SUM)  capacitor c=4.02112e-19
    C94  (sumn\#5 CIN\#2311)  capacitor c=97.9599a
    C105  (CIN\#2311 7)  capacitor c=600.375a
    C124  (CIN\#2311 net39)  capacitor c=1.60924e-19
    C262  (SUM\#1 sumn\#2312)  capacitor c=372.919a
    C269  (SUM\#1 7)  capacitor c=2.34459e-15
    C362  (sumn\#5 net39\#2)  capacitor c=98.7284a
    C383  (net39\#2 7)  capacitor c=40.547a
    C10  (vdd\#2 A\#2315)  capacitor c=14.2222a
    C200  (A\#2315 vss)  capacitor c=3.12185e-18
    C281  (sumn\#5 A\#2315)  capacitor c=604.18a
    C283  (A\#2315 7)  capacitor c=2.88509e-15
    C32  (vdd\#2 net47)  capacitor c=7.15979e-18
    C309  (A\#2315 net47)  capacitor c=655.272a
    C357  (sumn\#5 net47)  capacitor c=117.138a
    C396  (net39\#2 net47)  capacitor c=17.5562a
    C34  (vdd\#2 net43)  capacitor c=123.765a
    C245  (net43 vss)  capacitor c=3.55811e-18
    C380  (net43 7)  capacitor c=220.534a
    C402  (net39\#2 net43)  capacitor c=110.029a
    C35  (vdd\#2 net43\#2)  capacitor c=146.453a
    C311  (net43\#2 A\#2315)  capacitor c=171.272a
    C359  (sumn\#5 net43\#2)  capacitor c=11.2416a
    C381  (net43\#2 7)  capacitor c=273.215a
    C395  (net43\#2 net47)  capacitor c=84.6238a
    C404  (net43\#2 X45_5)  capacitor c=152.718a
    C312  (A\#2315 X45_5)  capacitor c=528.653a
    C397  (X45_5 net47)  capacitor c=161.018a
    C50  (CIN\#6 B\#2311)  capacitor c=297.188a
    C52  (CIN\#4 B\#2311)  capacitor c=516.613a
    C56  (CIN\#2311 B\#2311)  capacitor c=56.3713a
    C132  (B\#2311 vss)  capacitor c=7.07654e-18
    C162  (sumn\#5 B\#2311)  capacitor c=256.183a
    C172  (B\#2311 7)  capacitor c=7.67894e-15
    C51  (B\#9 CIN\#6)  capacitor c=1.84976e-15
    C53  (CIN\#4 B\#9)  capacitor c=65.38a
    C133  (B\#9 vss)  capacitor c=1.38631e-18
    C173  (B\#9 7)  capacitor c=10.9333f
    C54  (B\#7 CIN\#4)  capacitor c=559.233a
    C134  (B\#7 vss)  capacitor c=1.24898e-18
    C156  (B\#7 coutn)  capacitor c=1.59201e-15
    C158  (coutn\#2310 B\#7)  capacitor c=36.343a
    C174  (B\#7 7)  capacitor c=7.86837e-15
    C57  (vss CIN)  capacitor c=4.13856e-18
    C95  (7 CIN)  capacitor c=697.246a
    C46  (B CIN)  capacitor c=56.9458a
    C163  (7 B)  capacitor c=2.87643e-15
    C55  (CIN\#2 B)  capacitor c=659.561a
    C64  (CIN\#2 vss)  capacitor c=10.8796a
    C104  (CIN\#2 7)  capacitor c=4.49708e-15
    C87  (coutn\#8 CIN)  capacitor c=56.9553a
    C326  (coutn\#8 7)  capacitor c=425.318a
    C59  (CIN\#7 vss)  capacitor c=5.14167e-18
    C73  (CIN\#7 A\#2315)  capacitor c=34.5781a
    C97  (CIN\#7 7)  capacitor c=1.69613e-15
    C2  (vdd\#6 CIN\#7)  capacitor c=154.601a
    C29  (vdd\#6 net47\#2)  capacitor c=107.267a
    C120  (net47\#2 CIN\#7)  capacitor c=672.699a
    C358  (sumn\#5 net47\#2)  capacitor c=140.258a
    C38  (vdd\#6 X46_5)  capacitor c=46.1745a
    C39  (vdd\#6 X44_5)  capacitor c=335.066a
    C126  (CIN\#7 X44_5)  capacitor c=453.221a
    C398  (net47\#2 X44_5)  capacitor c=315.505a
    C47  (B\#2310 CIN\#7)  capacitor c=34.5781a
    C129  (B\#2310 vss)  capacitor c=1.29138e-18
    C165  (B\#2310 7)  capacitor c=2.29034e-15
    C403  (X46_5 net43)  capacitor c=152.718a
    C406  (net39\#2 X46_5)  capacitor c=163.003a
    C190  (B\#2314 X46_5)  capacitor c=526.552a
    C128  (B\#2314 vss)  capacitor c=14.1564a
    C143  (A\#2315 B\#2314)  capacitor c=34.5781a
    C79  (CIN\#6 A\#2312)  capacitor c=820.037a
    C146  (A\#2312 B\#2311)  capacitor c=732.849a
    C147  (B\#9 A\#2312)  capacitor c=141.536a
    C161  (sumn\#5 B\#2314)  capacitor c=361.525a
    C164  (B\#2314 7)  capacitor c=2.1893e-15
    C186  (B\#2314 net47)  capacitor c=30.7703a
    C188  (B\#2314 net43)  capacitor c=200.273a
    C189  (net39\#2 B\#2314)  capacitor c=257.173a
    C204  (A\#2312 vss)  capacitor c=13.1931a
    C291  (A\#2312 7)  capacitor c=7.59932e-15
    C3  (vdd\#7 B\#2310)  capacitor c=155.241a
    C14  (vdd\#4 coutn\#2313)  capacitor c=605.918a
    C84  (CIN\#6 coutn\#2313)  capacitor c=586.639a
    C217  (coutn\#2313 vss)  capacitor c=10.8214a
    C320  (coutn\#2313 7)  capacitor c=5.62205e-15
    C323  (coutn\#2311 7)  capacitor c=6.30053e-15
    C20  (vdd\#4 sumn\#9)  capacitor c=24.5896a
    C24  (net38\#4 vdd)  capacitor c=407.733a
    C376  (net38\#4 7)  capacitor c=3.21005e-15
    C25  (net38\#6 vdd\#2312)  capacitor c=84.6238a
    C4  (vdd\#2312 B\#2)  capacitor c=822.117a
    C131  (B\#2 vss)  capacitor c=2.0791e-18
    C167  (B\#2 7)  capacitor c=2.54178e-15
    C183  (net38\#6 B\#2)  capacitor c=189.444a
    C392  (net38\#6 X35_5)  capacitor c=175.027a
    C45  (vdd\#2312 X35_5)  capacitor c=136.992a
    C193  (B\#2 X35_5)  capacitor c=532.503a
    C344  (coutn\#9 X35_5)  capacitor c=28.8703a
    C28  (vdd\#2312 net37\#2)  capacitor c=17.9818a
    C44  (vdd\#2312 X36_5)  capacitor c=28.66a
    C119  (net37\#2 CIN\#2)  capacitor c=19.2077a
    C184  (net37\#2 B)  capacitor c=4.07873e-18
    C378  (net37\#2 7)  capacitor c=241.597a
    C388  (net37\#2 net38\#4)  capacitor c=108.479a
    C391  (net38\#4 X36_5)  capacitor c=305.366a
    C394  (net37\#2 X36_5)  capacitor c=152.132a
    C30  (net47\#4 vdd\#7)  capacitor c=107.267a
    C187  (net47\#4 B\#2310)  capacitor c=672.699a
    C40  (vdd\#7 X43_5)  capacitor c=328.08a
    C191  (B\#2310 X43_5)  capacitor c=453.221a
    C399  (net47\#4 X43_5)  capacitor c=316.082a
    C353  (net47\#4 sumn)  capacitor c=140.526a
    C90  (CIN\#6 sumn)  capacitor c=2.67441e-15
    C159  (B\#2310 sumn)  capacitor c=355.395a
    C144  (A\#2311 B\#2310)  capacitor c=34.5781a
    C160  (B\#9 sumn)  capacitor c=1.29328e-15
    C201  (A\#2311 vss)  capacitor c=3.52986e-18
    C224  (sumn vss)  capacitor c=69.5403a
    C255  (COUT\#3 sumn)  capacitor c=52.8059a
    C278  (A\#2311 sumn)  capacitor c=602.046a
    C284  (A\#2311 7)  capacitor c=2.85675e-15
    C317  (coutn\#2313 sumn)  capacitor c=759.429a
    C263  (sumn\#7 SUM\#1)  capacitor c=43.2818a
    C8  (vdd\#8 A\#2311)  capacitor c=155.241a
    C33  (vdd\#4 net47\#8)  capacitor c=42.066a
    C244  (net47\#8 vss)  capacitor c=65.8394a
    C336  (net47\#8 coutn\#2313)  capacitor c=178.784a
    C355  (net47\#8 sumn)  capacitor c=82.6549a
    C356  (sumn\#9 net47\#8)  capacitor c=75.0251a
    C379  (net47\#8 7)  capacitor c=1.00118e-15
    C31  (net47\#6 vdd\#8)  capacitor c=95.9263a
    C310  (net47\#6 A\#2311)  capacitor c=651.541a
    C354  (net47\#6 sumn)  capacitor c=140.526a
    C41  (vdd\#8 X42_5)  capacitor c=286.808a
    C400  (net47\#6 X42_5)  capacitor c=316.082a
    C313  (A\#2311 X42_5)  capacitor c=453.221a
    C80  (A\#2310 CIN\#6)  capacitor c=600.107a
    C148  (A\#2310 B\#9)  capacitor c=1.68368e-15
    C205  (A\#2310 vss)  capacitor c=5.33677e-18
    C279  (sumn\#3 A\#2310)  capacitor c=1.09026e-15
    C292  (A\#2310 7)  capacitor c=9.02966e-15
    C365  (sumn\#9 X41_5)  capacitor c=182.679a
    C401  (net47\#8 X41_5)  capacitor c=172.489a
    C337  (coutn\#2313 X41_5)  capacitor c=513.301a
    C155  (B\#9 coutn\#2312)  capacitor c=586.485a
    C272  (A\#2310 coutn\#2312)  capacitor c=600.776a
    C318  (sumn\#3 coutn\#2312)  capacitor c=82.6531a
    C322  (coutn\#2312 7)  capacitor c=6.34442e-15
    C60  (CIN\#3 vss)  capacitor c=23.3263a
    C74  (CIN\#3 A\#8)  capacitor c=12.2154a
    C83  (A\#6 CIN\#4)  capacitor c=600.16a
    C86  (coutn\#9 CIN\#3)  capacitor c=199.176a
    C98  (CIN\#3 7)  capacitor c=1.59774e-15
    C117  (net38\#2 CIN\#3)  capacitor c=208.864a
    C154  (A\#6 B\#7)  capacitor c=619.166a
    C294  (A\#6 7)  capacitor c=6.33332e-15
    C342  (coutn\#9 X38_5)  capacitor c=280.21a
    C390  (net38\#2 X38_5)  capacitor c=297.496a
    C127  (CIN\#3 X38_5)  capacitor c=445.713a
    C118  (CIN\#3 net37)  capacitor c=30.2997a
    C243  (net37 vss)  capacitor c=2.98583e-18
    C335  (coutn\#8 net37)  capacitor c=105.512a
    C377  (net37 7)  capacitor c=244.097a
    C387  (net38\#4 net37)  capacitor c=118.816a
    C61  (CIN\#1 vss)  capacitor c=23.3047a
    C101  (CIN\#1 7)  capacitor c=2.78243e-15
    C49  (CIN\#1 B\#6)  capacitor c=10.1661a
    C170  (B\#6 7)  capacitor c=2.24351e-15
    C150  (B\#7 A)  capacitor c=1.12653e-15
    C76  (CIN\#1 A)  capacitor c=369.548a
    C81  (CIN\#2 A)  capacitor c=282.449a
    C82  (A\#2 CIN\#2)  capacitor c=1.26748e-19
    C142  (A B)  capacitor c=1.34857e-15
    C152  (A\#2 B)  capacitor c=4.41175e-18
    C199  (A vss)  capacitor c=27.8717a
    C282  (7 A)  capacitor c=15.9583f
    C293  (A\#2 7)  capacitor c=35.4849a
    C71  (SUM\#1 CIN\#2312)  capacitor c=5.2202e-18
    C92  (sumn\#7 CIN\#2312)  capacitor c=306.766a
    C99  (CIN\#2312 7)  capacitor c=2.63008e-15
    C65  (vss\#1 CIN\#2312)  capacitor c=75.9552a
    C198  (vss\#1 SUM\#1)  capacitor c=109.82a
    C226  (vss\#1 sumn\#2312)  capacitor c=187.128a
    C351  (sumn\#2312 net5)  capacitor c=1.12473e-18
    C113  (CIN\#2312 net5)  capacitor c=83.616a
    C114  (CIN\#6 net5)  capacitor c=3.80386e-19
    C115  (CIN\#4 net5)  capacitor c=1.29005e-18
    C110  (CIN\#4 net9)  capacitor c=2.78347e-18
    C108  (CIN\#2312 net9)  capacitor c=8.74772e-18
    C109  (CIN\#6 net9)  capacitor c=8.20735e-19
    C78  (A\#2312 CIN\#5)  capacitor c=370.451a
    C100  (CIN\#5 7)  capacitor c=2.83119e-15
    C112  (CIN\#2311 net9)  capacitor c=2.50839e-19
    C116  (CIN\#2311 net5)  capacitor c=1.16256e-19
    C227  (sumn\#7 vss\#1)  capacitor c=91.0597a
    C240  (vss\#1 net5)  capacitor c=73.2456a
    C239  (vss\#2 net9)  capacitor c=20.5569a
    C350  (sumn\#7 net9)  capacitor c=12.4192a
    C352  (sumn\#7 net5)  capacitor c=56.9465a
    C372  (net9 7)  capacitor c=297.483a
    C374  (net5 7)  capacitor c=367.889a
    C241  (vss\#2 net5\#2)  capacitor c=70.6982a
    C375  (net5\#2 7)  capacitor c=191.085a
    C386  (net5\#2 net9)  capacitor c=50.7743a
    C48  (B\#8 CIN\#5)  capacitor c=10.1661a
    C169  (B\#8 7)  capacitor c=2.22092e-15
    C66  (vss\#8 CIN\#5)  capacitor c=101.548a
    C75  (CIN\#5 A\#2314)  capacitor c=10.1661a
    C287  (A\#2314 7)  capacitor c=1.57078e-15
    C77  (A\#4 CIN\#1)  capacitor c=10.1661a
    C290  (A\#4 7)  capacitor c=1.59739e-15
    C88  (coutn\#5 CIN\#1)  capacitor c=171.918a
    C276  (coutn\#5 A)  capacitor c=95.7583a
    C327  (coutn\#5 7)  capacitor c=679.813a
    C157  (coutn\#3 B\#6)  capacitor c=673.868a
    C325  (coutn\#3 7)  capacitor c=521.495a
    C106  (CIN\#1 net3)  capacitor c=169.552a
    C295  (net3 A)  capacitor c=11.302a
    C329  (coutn\#5 net3)  capacitor c=50.7743a
    C220  (vss\#2316 coutn\#5)  capacitor c=11.228a
    C211  (vss\#2316 A)  capacitor c=352.557a
    C212  (vss\#2316 A\#4)  capacitor c=424.978a
    C214  (A\#2 vss\#2316)  capacitor c=1.39404e-18
    C366  (net3 7)  capacitor c=608.617a
    C107  (CIN\#5 net20)  capacitor c=596.183a
    C234  (vss\#8 net20)  capacitor c=56.6133a
    C300  (A\#2314 net20)  capacitor c=6.92484e-18
    C301  (A\#2312 net20)  capacitor c=173.205a
    C393  (X37_5 net37)  capacitor c=162.993a
    C153  (A\#2 B\#3)  capacitor c=1.03969e-20
    C136  (vss\#2314 B)  capacitor c=20.943a
    C181  (net5\#2 B\#2313)  capacitor c=118.603a
    C192  (B\#1 X36_5)  capacitor c=520.736a
    C316  (A\#1 X36_5)  capacitor c=514.402a
    C297  (net3\#2 A\#4)  capacitor c=194.008a
    C141  (B\#9 COUT)  capacitor c=1.04443e-15
    C149  (A\#5 B\#9)  capacitor c=86.324a
    C305  (net9\#2 A\#2312)  capacitor c=20.7311a
    C275  (coutn\#8 A\#1)  capacitor c=176.814a
    C343  (coutn\#8 X37_5)  capacitor c=153.954a
    C286  (A\#1 7)  capacitor c=4.16715e-15
    C315  (A\#1 X37_5)  capacitor c=531.108a
    C247  (X37_5 vss)  capacitor c=5.72996e-18
    C203  (A\#1 vss)  capacitor c=33.3074a
    C130  (B\#1 vss)  capacitor c=9.03878e-18
    C166  (B\#1 7)  capacitor c=617.622a
    C138  (B\#3 vss)  capacitor c=15.2621a
    C175  (B\#3 7)  capacitor c=6.27214e-15
    C151  (B\#3 A)  capacitor c=2.89232e-18
    C168  (B\#2313 7)  capacitor c=2.29102e-15
    C139  (vss\#2 B\#2313)  capacitor c=25.7499a
    C145  (A\#2314 B\#2313)  capacitor c=10.1661a
    C171  (B\#4 7)  capacitor c=2.16339e-15
    C137  (vss\#2314 B\#4)  capacitor c=808.681a
    C213  (vss\#2314 A)  capacitor c=35.2518a
    C176  (net3\#4 B\#4)  capacitor c=114.863a
    C231  (net3\#4 vss)  capacitor c=482.018a
    C368  (net3\#4 7)  capacitor c=655.91a
    C179  (B\#2313 net9)  capacitor c=637.96a
    C304  (net9\#2 A\#2314)  capacitor c=137.701a
    C373  (net9\#2 7)  capacitor c=686.593a
    C182  (net38\#4 B\#1)  capacitor c=222.441a
    C307  (net38\#4 A\#1)  capacitor c=9.33658e-18
    C185  (net37\#2 B\#1)  capacitor c=184.529a
    C308  (net37\#2 A\#1)  capacitor c=380.316a
    C206  (vss\#7 A\#2314)  capacitor c=103.456a
    C238  (net9\#2 vss\#7)  capacitor c=47.9632a
    C222  (vss\#4 coutn\#2312)  capacitor c=560.728a
    C229  (vss\#6 7)  capacitor c=77.1502f
    C237  (net20\#6 vss)  capacitor c=4.25977e-18
    C332  (net20\#6 coutn\#2312)  capacitor c=87.2733a
    C140  (vss\#6 B\#6)  capacitor c=23.7445a
    C177  (net1\#2 B\#6)  capacitor c=114.863a
    C233  (vss\#6 net1\#2)  capacitor c=98.6147a
    C331  (coutn\#3 net1\#2)  capacitor c=170.439a
    C370  (net1\#2 7)  capacitor c=599.282a
    C196  (vss\#6 COUT)  capacitor c=502.591a
    C249  (coutn\#2312 COUT)  capacitor c=658.87a
    C254  (sumn\#3 COUT)  capacitor c=210.915a
    C256  (7 COUT)  capacitor c=21.2826f
    C259  (net20\#6 COUT)  capacitor c=129.82a
    C349  (net20\#6 sumn\#3)  capacitor c=41.9258a
    C280  (sumn\#3 A\#5)  capacitor c=14.25a
    C248  (A\#5 COUT)  capacitor c=1.15204e-15
    C274  (coutn\#3 A\#5)  capacitor c=1.17461e-15
    C219  (coutn\#3 vss\#2313)  capacitor c=65.9764a
    C210  (vss\#2313 A\#5)  capacitor c=115.902a
    C296  (net3\#2 A)  capacitor c=8.77126e-18
    C230  (vss\#2316 net3\#2)  capacitor c=90.5588a
    C367  (net3\#2 7)  capacitor c=1.2568e-15
    C384  (net1\#2 net3)  capacitor c=10.5723a
    C232  (vss\#6 net1)  capacitor c=160.089a
    C299  (A\#5 net1)  capacitor c=5.69523e-18
    C369  (net1 7)  capacitor c=613.293a
    C208  (vss\#2311 A\#5)  capacitor c=92.5414a
    C195  (COUT\#4 vss\#2311)  capacitor c=115.006a
    C223  (vss\#6 coutn\#2311)  capacitor c=1.14084e-15
    C250  (coutn\#2311 COUT)  capacitor c=341.926a
    C258  (COUT\#4 7)  capacitor c=568.376a
    C273  (A\#5 coutn\#2311)  capacitor c=582.645a
    C330  (coutn\#2311 net1)  capacitor c=3.09607e-18
    C135  (vss\#9 B\#8)  capacitor c=112.091a
    C178  (net20\#2 B\#8)  capacitor c=627.49a
    C235  (vss\#9 net20\#2)  capacitor c=75.3037a
    C385  (net9\#2 net20)  capacitor c=10.9269a
    C236  (vss\#2310 net20\#4)  capacitor c=72.3442a
    C371  (net20\#4 7)  capacitor c=2.89926e-15
    C207  (vss\#2310 A\#9)  capacitor c=110.005a
    C288  (A\#9 7)  capacitor c=1.65993e-15
    C289  (A\#7 7)  capacitor c=1.83477e-15
    C209  (vss\#2313 A\#7)  capacitor c=524.659a
    C298  (A\#7 net1)  capacitor c=117.579a
    C215  (A\#6 vss\#2313)  capacitor c=172.89a
    C302  (net20\#4 A\#9)  capacitor c=416.514a
    C303  (net20\#4 A\#2310)  capacitor c=541.912a
    MX34_M0_unmatched  (SUM\#1 sumn\#2312 vss\#1 vss\#1)  nch w=2e-06 \
        l=1e-06 as=0 ad=5e-12 ps=0 pd=9e-06 sa=2e-06 sb=2e-06
    MX33_M0_unmatched  (sumn\#7 CIN\#2312 net5 net5)  nch w=2e-06 l=1e-06 \
        as=0 ad=5e-12 ps=0 pd=9e-06 sa=2e-06 sb=2e-06
    MX23_M0_unmatched  (coutn\#5 CIN\#1 net3 net3)  nch w=2e-06 l=1e-06 as=0 \
        ad=5e-12 ps=0 pd=9e-06 sa=2e-06 sb=2e-06
    MX30_M0_unmatched  (net20 CIN\#5 vss\#8 vss\#8)  nch w=2e-06 l=1e-06 \
        as=0 ad=5e-12 ps=0 pd=9e-06 sa=2e-06 sb=2e-06
    MX32_M0_unmatched  (net5\#2 B\#2313 net9 net9)  nch w=2e-06 l=1e-06 as=0 \
        ad=5e-12 ps=0 pd=9e-06 sa=2e-06 sb=2e-06
    MX22_M0_unmatched  (net3\#2 A\#4 vss\#2316 vss\#2316)  nch w=2e-06 \
        l=1e-06 as=0 ad=5e-12 ps=0 pd=9e-06 sa=2e-06 sb=2e-06
    MX21_M0_unmatched  (net3\#4 B\#4 vss\#2314 vss\#2314)  nch w=2e-06 \
        l=1e-06 as=0 ad=5e-12 ps=0 pd=9e-06 sa=2e-06 sb=2e-06
    MX31_M0_unmatched  (net9\#2 A\#2314 vss\#7 vss\#7)  nch w=2e-06 \
        l=1e-06 as=0 ad=5e-12 ps=0 pd=9e-06 sa=2e-06 sb=2e-06
    MX24_M0_unmatched  (coutn\#3 B\#6 net1\#2 net1\#2)  nch w=2e-06 l=1e-06 \
        as=0 ad=5e-12 ps=0 pd=9e-06 sa=2e-06 sb=2e-06
    MX27_M0_unmatched  (sumn\#3 coutn\#2312 net20\#6 net20\#6)  nch w=2e-06 \
        l=1e-06 as=0 ad=5e-12 ps=0 pd=9e-06 sa=2e-06 sb=2e-06
    MX26_M0_unmatched  (COUT\#4 coutn\#2311 vss\#2311 vss\#2311)  nch \
        w=2e-06 l=1e-06 as=0 ad=5e-12 ps=0 pd=9e-06 sa=2e-06 sb=2e-06
    MX29_M0_unmatched  (net20\#2 B\#8 vss\#9 vss\#9)  nch w=2e-06 l=1e-06 \
        as=0 ad=5e-12 ps=0 pd=9e-06 sa=2e-06 sb=2e-06
    MX28_M0_unmatched  (net20\#4 A\#9 vss\#2310 vss\#2310)  nch w=2e-06 \
        l=1e-06 as=0 ad=5e-12 ps=0 pd=9e-06 sa=2e-06 sb=2e-06
    MX25_M0_unmatched  (net1 A\#7 vss\#2313 vss\#2313)  nch w=2e-06 \
        l=1e-06 as=0 ad=5e-12 ps=0 pd=9e-06 sa=2e-06 sb=2e-06
    MX48_M0_unmatched  (SUM\#2 sumn\#2310 vdd\#1 vdd\#1)  pch w=4e-06 \
        l=1e-06 as=0 ad=1e-11 ps=0 pd=1.3e-05 sa=2e-06 sb=2e-06
    MX40_M0_unmatched  (COUT\#3 coutn\#2314 vdd\#9 vdd\#9)  pch w=4e-06 \
        l=1e-06 as=0 ad=1e-11 ps=0 pd=1.3e-05 sa=2e-06 sb=2e-06
    MX39_M0_unmatched  (net38 A\#8 vdd\#2311 vdd\#2311)  pch w=4e-06 \
        l=1e-06 as=0 ad=1e-11 ps=0 pd=1.3e-05 sa=2e-06 sb=2e-06
    MX47_M0_unmatched  (sumn\#8 CIN\#2310 net39 net39)  pch w=4e-06 l=1e-06 \
        as=0 ad=1e-11 ps=0 pd=1.3e-05 sa=2e-06 sb=2e-06
    MX45_M0_unmatched  (net43\#2 A\#2315 net47 net47)  pch w=4e-06 l=1e-06 \
        as=0 ad=1e-11 ps=0 pd=1.3e-05 sa=2e-06 sb=2e-06
    MX44_M0_unmatched  (net47\#2 CIN\#7 vdd\#6 vdd\#6)  pch w=4e-06 \
        l=1e-06 as=0 ad=1e-11 ps=0 pd=1.3e-05 sa=2e-06 sb=2e-06
    MX46_M0_unmatched  (net39\#2 B\#2314 net43 net43)  pch w=4e-06 l=1e-06 \
        as=0 ad=1e-11 ps=0 pd=1.3e-05 sa=2e-06 sb=2e-06
    MX35_M0_unmatched  (net38\#6 B\#2 vdd\#2312 vdd\#2312)  pch w=4e-06 \
        l=1e-06 as=0 ad=1e-11 ps=0 pd=1.3e-05 sa=2e-06 sb=2e-06
    MX43_M0_unmatched  (net47\#4 B\#2310 vdd\#7 vdd\#7)  pch w=4e-06 \
        l=1e-06 as=0 ad=1e-11 ps=0 pd=1.3e-05 sa=2e-06 sb=2e-06
    MX42_M0_unmatched  (net47\#6 A\#2311 vdd\#8 vdd\#8)  pch w=4e-06 \
        l=1e-06 as=0 ad=1e-11 ps=0 pd=1.3e-05 sa=2e-06 sb=2e-06
    MX41_M0_unmatched  (sumn\#9 coutn\#2313 net47\#8 net47\#8)  pch w=4e-06 \
        l=1e-06 as=0 ad=1e-11 ps=0 pd=1.3e-05 sa=2e-06 sb=2e-06
    MX38_M0_unmatched  (coutn\#9 CIN\#3 net38\#2 net38\#2)  pch w=4e-06 \
        l=1e-06 as=0 ad=1e-11 ps=0 pd=1.3e-05 sa=2e-06 sb=2e-06
    MX37_M0_unmatched  (coutn\#8 A\#1 net37 net37)  pch w=4e-06 l=1e-06 as=0 \
        ad=1e-11 ps=0 pd=1.3e-05 sa=2e-06 sb=2e-06
    MX36_M0_unmatched  (net37\#2 B\#1 net38\#4 net38\#4)  pch w=4e-06 \
        l=1e-06 as=0 ad=1e-11 ps=0 pd=1.3e-05 sa=2e-06 sb=2e-06
ends ADDFX1
