// DFFSX1
simulator lang=spectre insensitive=yes
global vss vdd
subckt DFFSX1 D Q SN QN CK
    C39  (Y4\#2313 vss)  capacitor c=4.68966e-18
    C116  (vdd\#8 Q\#4)  capacitor c=333.906a
    C1  (D\#4 vss)  capacitor c=4.19769e-18
    C11  (SN vss)  capacitor c=32.5913a
    C34  (Y4 vss)  capacitor c=7.63147e-18
    C41  (Y4\#2312 vss)  capacitor c=44.4445a
    C48  (Y2\#2317 vss)  capacitor c=42.6034a
    C78  (vss\#3 10)  capacitor c=75.9712f
    C94  (vdd\#1 D\#4)  capacitor c=239.793a
    C95  (Y4\#9 D\#4)  capacitor c=155.445a
    C99  (D\#4 10)  capacitor c=2.02949e-15
    C148  (CK SN)  capacitor c=569.111a
    C152  (Y4 SN)  capacitor c=1.25037e-15
    C159  (Y2\#2317 SN)  capacitor c=562.738a
    C169  (10 SN)  capacitor c=11.767f
    C222  (Y4\#9 vdd\#1)  capacitor c=144.55a
    C266  (Y4\#6 CK)  capacitor c=1.37566e-18
    C267  (Y4\#6 CK\#7)  capacitor c=1.09418e-19
    C268  (Y4\#2312 CK)  capacitor c=668.61a
    C269  (Y4\#2312 CK\#7)  capacitor c=51.2742a
    C277  (10 CK)  capacitor c=15.1443f
    C283  (CK\#7 10)  capacitor c=779.032a
    C305  (Y2\#2317 Y4)  capacitor c=311.151a
    C308  (Y4\#6 Y2\#2317)  capacitor c=2.53748e-18
    C310  (Y4\#2312 Y2\#2317)  capacitor c=1.18908e-15
    C335  (Y4\#6 10)  capacitor c=28.664a
    C336  (Y4\#2312 10)  capacitor c=27.85f
    C369  (Y2\#2317 10)  capacitor c=20.5811f
    C4  (D\#2 vss)  capacitor c=6.71444e-18
    C97  (D\#2 Y4\#2312)  capacitor c=28.4543a
    C101  (D\#2 10)  capacitor c=5.09414e-15
    C103  (D\#4 X37_5)  capacitor c=504.33a
    C250  (vdd\#1 X37_5)  capacitor c=479.383a
    C345  (Y4\#9 X37_5)  capacitor c=319.404a
    C38  (Y4\#2310 vss)  capacitor c=6.15639e-18
    C5  (Q vss)  capacitor c=26.0763a
    C118  (CK Q)  capacitor c=1.25663e-15
    C122  (Y4\#6 Q)  capacitor c=2.44604e-18
    C125  (Y4\#2312 Q)  capacitor c=1.14623e-15
    C136  (10 Q)  capacitor c=13.5536f
    C6  (Q\#2310 vss)  capacitor c=8.03257e-18
    C128  (Y2\#2317 Q\#2310)  capacitor c=586.485a
    C137  (Q\#2310 10)  capacitor c=6.45432e-15
    C7  (Q\#4 vss)  capacitor c=8.5777e-18
    C120  (Q\#4 CK)  capacitor c=3.52201e-18
    C124  (Y4\#6 Q\#4)  capacitor c=1.40533e-20
    C127  (Y4\#2312 Q\#4)  capacitor c=6.58549e-18
    C129  (Q\#4 Y2\#2317)  capacitor c=1.05231e-15
    C139  (Q\#4 10)  capacitor c=10.3809f
    C8  (Q\#6 vss)  capacitor c=19.0119a
    C130  (Q\#6 Y2\#2317)  capacitor c=88.2223a
    C9  (vss\#3 Q\#2311)  capacitor c=62.1668a
    C119  (Q\#2311 CK)  capacitor c=555.248a
    C121  (CK\#7 Q\#2311)  capacitor c=44.1637a
    C123  (Y4\#6 Q\#2311)  capacitor c=1.29856e-18
    C126  (Y4\#2312 Q\#2311)  capacitor c=608.515a
    C138  (Q\#2311 10)  capacitor c=4.10196e-15
    C10  (vss\#3 Q\#3)  capacitor c=157.255a
    C106  (QN\#2 Q)  capacitor c=72.7298a
    C194  (QN\#2 CK)  capacitor c=652.668a
    C196  (CK\#7 QN\#2)  capacitor c=40.6142a
    C201  (Y4\#6 QN\#2)  capacitor c=2.43971e-18
    C203  (Y4\#2312 QN\#2)  capacitor c=1.08645e-15
    C212  (QN\#2 10)  capacitor c=13.4692f
    C12  (SN\#6 vss)  capacitor c=15.4147a
    C104  (Q\#6 SN\#6)  capacitor c=820.551a
    C170  (SN\#6 10)  capacitor c=2.47694e-15
    C13  (SN\#4 vss)  capacitor c=2.58726e-18
    C171  (SN\#4 10)  capacitor c=2.54547e-15
    C15  (SN\#2 vss)  capacitor c=6.40453e-18
    C153  (SN\#2 Y4)  capacitor c=2.14696e-18
    C174  (SN\#2 10)  capacitor c=5.63069e-15
    C16  (SN\#7 vss)  capacitor c=9.80901e-19
    C151  (SN\#7 CK)  capacitor c=26.2309a
    C156  (SN\#7 Y4)  capacitor c=43.7313a
    C162  (SN\#7 Y2\#2317)  capacitor c=32.5369a
    C175  (SN\#7 10)  capacitor c=393.975a
    C18  (QN\#5 vss)  capacitor c=22.8705a
    C198  (QN\#5 Y4)  capacitor c=15.871a
    C204  (Y2\#2317 QN\#5)  capacitor c=547.574a
    C210  (QN\#5 10)  capacitor c=3.70259e-15
    C19  (QN\#8 vss)  capacitor c=34.4124a
    C107  (QN\#8 Q\#2310)  capacitor c=830.154a
    C108  (QN\#8 Q\#4)  capacitor c=83.1637a
    C205  (QN\#8 Y2\#2317)  capacitor c=1.22178e-15
    C20  (vss\#3 QN\#3)  capacitor c=609.51a
    C110  (Q\#3 QN\#3)  capacitor c=119.102a
    C195  (QN\#3 CK)  capacitor c=526.288a
    C197  (CK\#7 QN\#3)  capacitor c=30.3123a
    C213  (QN\#3 10)  capacitor c=5.5175e-15
    C21  (vss\#3 QN\#6)  capacitor c=72.6356a
    C23  (vdd\#2319 vss)  capacitor c=36.2891a
    C24  (vdd\#27 vss)  capacitor c=36.6029a
    C25  (vdd\#2314 vss)  capacitor c=38.2754a
    C147  (vdd\#2314 SN\#4)  capacitor c=236.031a
    C26  (vdd\#7 vss)  capacitor c=56.8827a
    C115  (vdd\#7 Q\#2310)  capacitor c=1.21451e-15
    C27  (CK\#6 vss)  capacitor c=27.6286a
    C278  (CK\#6 10)  capacitor c=3.20525e-15
    C28  (CK\#4 vss)  capacitor c=30.8672a
    C279  (CK\#4 10)  capacitor c=3.18677e-15
    C29  (vss\#9 CK)  capacitor c=302.165a
    C32  (CK\#7 vss\#7)  capacitor c=11.7101a
    C33  (vss\#3 CK\#8)  capacitor c=67.2465a
    C280  (CK\#8 10)  capacitor c=784.744a
    C35  (Y4\#5 vss)  capacitor c=13.3327a
    C330  (Y4\#5 10)  capacitor c=1.82229e-15
    C36  (Y4\#4 vss)  capacitor c=20.0739a
    C225  (vdd\#27 Y4\#4)  capacitor c=234.958a
    C331  (Y4\#4 10)  capacitor c=1.93084e-15
    C37  (Y4\#3 vss)  capacitor c=71.9342a
    C333  (Y4\#3 10)  capacitor c=2.13172e-15
    C40  (Y4\#2 vss)  capacitor c=8.0678e-18
    C154  (Y4\#2 SN)  capacitor c=579.826a
    C155  (Y4\#2 SN\#2)  capacitor c=6.106e-18
    C334  (Y4\#2 10)  capacitor c=5.49677e-15
    C42  (vss\#3 Y4\#8)  capacitor c=13.1181a
    C332  (Y4\#8 10)  capacitor c=1.53153e-15
    C43  (Y2 vss)  capacitor c=4.51706e-18
    C44  (Y2\#2318 vss)  capacitor c=22.0038a
    C363  (Y2\#2318 10)  capacitor c=1.2281e-15
    C45  (Y2\#2316 vss)  capacitor c=8.64028e-18
    C364  (Y2\#2316 10)  capacitor c=615.039a
    C46  (Y2\#4 vss)  capacitor c=12.2606a
    C365  (Y2\#4 10)  capacitor c=603.937a
    C47  (Y2\#3 vss)  capacitor c=64.3543a
    C158  (Y2\#3 SN)  capacitor c=1.15868e-15
    C160  (SN\#2 Y2\#3)  capacitor c=12.2017a
    C304  (Y2\#3 Y4)  capacitor c=1.48862e-15
    C368  (Y2\#3 10)  capacitor c=7.48169e-15
    C49  (vss\#7 Y2\#20)  capacitor c=182.918a
    C270  (Y2\#20 CK)  capacitor c=556.078a
    C273  (CK\#7 Y2\#20)  capacitor c=44.2297a
    C366  (Y2\#20 10)  capacitor c=2.61812e-15
    C50  (vss\#9 Y2\#2315)  capacitor c=182.446a
    C157  (Y2\#2315 SN)  capacitor c=288.962a
    C271  (Y2\#2315 CK)  capacitor c=578.939a
    C367  (Y2\#2315 10)  capacitor c=2.54359e-15
    C51  (Y2\#2310 vss)  capacitor c=3.39673e-18
    C52  (Y2\#2311 vss)  capacitor c=8.82143e-18
    C53  (Y2\#6 vss)  capacitor c=3.43237e-18
    C54  (Y2\#2 vss)  capacitor c=19.7143a
    C371  (Y2\#2 10)  capacitor c=4.44785e-15
    C356  (Y1\#4 Y2\#2)  capacitor c=764.351a
    C61  (Y1\#4 vss)  capacitor c=51.7048a
    C166  (Y1\#4 SN\#2)  capacitor c=543.591a
    C312  (Y1\#4 Y4)  capacitor c=589.164a
    C313  (Y1\#4 Y4\#2)  capacitor c=670.883a
    C339  (Y4\#2 net7)  capacitor c=2.06098e-18
    C180  (net7 SN)  capacitor c=50.3561a
    C182  (SN\#2 net7)  capacitor c=5.30288e-19
    C355  (Y1\#4 Y2)  capacitor c=136.709a
    C374  (Y2\#3 net7)  capacitor c=206.908a
    C388  (Y1\#4 10)  capacitor c=17.5391f
    C416  (net7 10)  capacitor c=367.614a
    C55  (Y2\#2313 vss)  capacitor c=6.17885e-18
    C132  (Y2\#2313 Q\#4)  capacitor c=75.1085a
    C161  (Y2\#2313 SN)  capacitor c=325.054a
    C163  (SN\#7 Y2\#2313)  capacitor c=2.32232e-18
    C206  (Y2\#2313 QN\#5)  capacitor c=39.0831a
    C306  (Y2\#2313 Y4)  capacitor c=632.471a
    C309  (Y4\#6 Y2\#2313)  capacitor c=2.00297e-20
    C372  (Y2\#2313 10)  capacitor c=4.78739e-15
    C56  (Y2\#2314 vss)  capacitor c=2.59784e-19
    C133  (Y2\#2314 Q\#6)  capacitor c=1.61062e-18
    C307  (Y2\#2314 Y4)  capacitor c=7.60574e-19
    C373  (Y2\#2314 10)  capacitor c=192.326a
    C135  (Q\#5 Y2\#2313)  capacitor c=16.9975a
    C111  (Q\#5 QN\#5)  capacitor c=821.858a
    C134  (Q\#5 Y2\#2317)  capacitor c=175.342a
    C58  (Y1\#9 vss)  capacitor c=13.3271a
    C350  (Y2\#2311 Y1\#9)  capacitor c=244.733a
    C386  (Y1\#9 10)  capacitor c=1.25758e-15
    C59  (Y1\#2 vss)  capacitor c=18.4189a
    C354  (Y1\#2 Y2\#3)  capacitor c=182.054a
    C391  (Y1\#2 net7)  capacitor c=47.5918a
    C164  (Y1 SN)  capacitor c=1.42527e-15
    C349  (Y2\#5 Y1)  capacitor c=118.543a
    C351  (Y2\#6 Y1)  capacitor c=66.6755a
    C63  (Y1\#2311 vss)  capacitor c=1.06053e-18
    C167  (Y1\#2311 SN)  capacitor c=1.62956e-15
    C168  (Y1\#2311 SN\#2)  capacitor c=9.21832e-19
    C315  (Y1\#2311 Y4)  capacitor c=303.909a
    C357  (Y1\#2311 Y2\#6)  capacitor c=15.3045a
    C370  (Y2\#5 10)  capacitor c=4.02162e-15
    C390  (Y1\#2311 10)  capacitor c=3.49607e-15
    C57  (vss\#5 Y2\#5)  capacitor c=231.167a
    C379  (net3\#2 Y2\#2315)  capacitor c=83.616a
    C85  (vss\#5 net3\#2)  capacitor c=104.004a
    C288  (net3\#2 CK)  capacitor c=68.4915a
    C421  (net3\#2 10)  capacitor c=221.343a
    C17  (vss\#5 SN\#8)  capacitor c=61.3824a
    C149  (SN\#8 CK)  capacitor c=282.784a
    C172  (SN\#8 10)  capacitor c=1.36081e-15
    C186  (SN\#7 net3)  capacitor c=1.11442e-19
    C84  (vss\#5 net3)  capacitor c=73.7603a
    C184  (net3 SN)  capacitor c=1.72444e-18
    C185  (SN\#8 net3)  capacitor c=83.616a
    C287  (net3 CK)  capacitor c=60.7789a
    C420  (net3 10)  capacitor c=220.204a
    C289  (net3\#2 CK\#3)  capacitor c=1.12473e-18
    C281  (CK\#3 10)  capacitor c=759.296a
    C22  (vss\#5 QN\#4)  capacitor c=496.313a
    C109  (Q\#3 QN\#4)  capacitor c=242.567a
    C193  (QN\#4 CK)  capacitor c=594.891a
    C199  (QN\#4 Y4)  capacitor c=527.23a
    C200  (Y4\#6 QN\#4)  capacitor c=5.53091e-19
    C211  (QN\#4 10)  capacitor c=5.65353e-15
    C215  (net6\#2 QN\#3)  capacitor c=1.83462e-18
    C89  (vss\#3 net6\#2)  capacitor c=72.6564a
    C141  (net6\#2 Q\#2311)  capacitor c=83.616a
    C216  (QN\#6 net6\#2)  capacitor c=39.8112a
    C105  (Q\#2311 QN)  capacitor c=185.07a
    C202  (Y4\#2312 QN)  capacitor c=56.8151a
    C190  (QN\#7 vdd\#2319)  capacitor c=144.572a
    C293  (net6\#2 CK)  capacitor c=63.4452a
    C294  (CK\#7 net6\#2)  capacitor c=10.0912a
    C425  (net6\#2 10)  capacitor c=221.343a
    C88  (vss\#3 net6)  capacitor c=105.108a
    C292  (net6 CK)  capacitor c=63.427a
    C424  (net6 10)  capacitor c=221.122a
    C30  (vss\#2310 CK\#3)  capacitor c=187.137a
    C31  (CK\#2 vss\#2310)  capacitor c=14.5488a
    C83  (vss\#5 net9)  capacitor c=120.707a
    C150  (CK\#2 SN)  capacitor c=609.738a
    C265  (CK\#2 Y4)  capacitor c=612.647a
    C314  (Y1\#2310 Y4)  capacitor c=24.6063a
    C62  (Y1\#2310 vss)  capacitor c=1.2982e-18
    C282  (CK\#2 10)  capacitor c=5.35847e-15
    C284  (CK\#3 net9)  capacitor c=101.713a
    C377  (Y2\#5 net9)  capacitor c=9.41027e-18
    C375  (net7\#2 Y2\#5)  capacitor c=7.92231e-18
    C81  (net7\#2 vss)  capacitor c=69.274a
    C338  (net7\#2 Y4\#3)  capacitor c=221.572a
    C376  (net7\#2 Y2\#6)  capacitor c=1.03341e-18
    C389  (Y1\#2310 10)  capacitor c=308.384a
    C417  (net7\#2 10)  capacitor c=232.025a
    C418  (net9 10)  capacitor c=510.436a
    C82  (net9\#2 vss)  capacitor c=1.54983e-18
    C183  (net9\#2 SN)  capacitor c=136.445a
    C285  (net9\#2 CK)  capacitor c=42.4576a
    C286  (CK\#2 net9\#2)  capacitor c=128.953a
    C378  (Y2\#6 net9\#2)  capacitor c=52.2629a
    C419  (net9\#2 10)  capacitor c=901.451a
    C64  (vss\#5 Y1\#2312)  capacitor c=12.257a
    C352  (Y2\#6 Y1\#2312)  capacitor c=115.495a
    C392  (net9\#2 Y1\#2312)  capacitor c=87.2498a
    C387  (Y1\#2312 10)  capacitor c=840.282a
    C181  (SN\#3 net7)  capacitor c=2.90054e-18
    C173  (SN\#3 10)  capacitor c=1.40407e-15
    C179  (SN\#2 net8\#2)  capacitor c=3.98171e-18
    C80  (net8\#2 vss)  capacitor c=104.004a
    C177  (net8\#2 SN)  capacitor c=8.04463e-18
    C176  (net8 SN)  capacitor c=10.21a
    C79  (net8 vss)  capacitor c=76.0093a
    C178  (net8\#2 SN\#3)  capacitor c=83.616a
    C337  (Y4\#3 net8)  capacitor c=83.3415a
    C432  (net7\#2 net8)  capacitor c=46.0379a
    C414  (net8 10)  capacitor c=234.991a
    C415  (net8\#2 10)  capacitor c=296.794a
    C14  (vss\#6 SN\#3)  capacitor c=167.567a
    C359  (Y2\#8 Y1\#2310)  capacitor c=43.697a
    C272  (Y2\#8 CK\#4)  capacitor c=840.346a
    C358  (Y2\#8 Y1\#4)  capacitor c=599.312a
    C234  (Y2\#2314 vdd\#23)  capacitor c=1.50063e-18
    C227  (vdd\#23 Y2\#2316)  capacitor c=236.503a
    C228  (Y2\#2310 vdd\#23)  capacitor c=123.469a
    C232  (vdd\#26 Y2)  capacitor c=19.7488a
    C233  (vdd\#26 Y2\#4)  capacitor c=234.798a
    C60  (Y1\#6 vss)  capacitor c=10.0074a
    C165  (Y1\#6 SN\#4)  capacitor c=415.439a
    C239  (Y1\#6 vdd\#2314)  capacitor c=194.385a
    C189  (SN\#4 X23_5)  capacitor c=531.582a
    C264  (vdd\#2314 X23_5)  capacitor c=181.705a
    C396  (Y1\#6 X23_5)  capacitor c=406.72a
    C230  (Y2\#2311 vdd)  capacitor c=52.1384a
    C238  (Y1\#8 vdd\#27)  capacitor c=176.041a
    C311  (Y1\#8 Y4\#4)  capacitor c=335.337a
    C236  (Y1\#7 vdd)  capacitor c=53.0681a
    C237  (vdd\#26 Y1\#7)  capacitor c=78.277a
    C353  (Y1\#7 Y2\#4)  capacitor c=189.694a
    C262  (vdd\#26 X25_5)  capacitor c=162.469a
    C385  (Y2\#4 X25_5)  capacitor c=510.168a
    C394  (Y1\#7 X25_5)  capacitor c=188.398a
    C263  (vdd\#27 X24_5)  capacitor c=148.996a
    C348  (Y4\#4 X24_5)  capacitor c=531.824a
    C395  (Y1\#8 X24_5)  capacitor c=148.996a
    C65  (Y3 vss)  capacitor c=3.10197e-18
    C208  (QN\#8 Y3)  capacitor c=10.8556a
    C360  (Y2\#2317 Y3)  capacitor c=731.745a
    C66  (Y3\#2314 vss)  capacitor c=5.83465e-18
    C316  (Y4\#2310 Y3\#2314)  capacitor c=194.696a
    C397  (Y3\#2314 10)  capacitor c=593.04a
    C67  (Y3\#4 vss)  capacitor c=8.71067e-18
    C207  (QN\#7 Y3\#4)  capacitor c=139.36a
    C244  (vdd\#2319 Y3\#4)  capacitor c=236.009a
    C398  (Y3\#4 10)  capacitor c=615.039a
    C217  (QN\#7 X32_5)  capacitor c=318.488a
    C255  (vdd\#2319 X32_5)  capacitor c=188.398a
    C413  (Y3\#4 X32_5)  capacitor c=503.965a
    C74  (Y3\#2 vss)  capacitor c=5.50989e-18
    C209  (Y3\#2 QN\#8)  capacitor c=15.8507a
    C320  (Y4\#6 Y3\#2)  capacitor c=1.30464e-18
    C327  (Y4\#2312 Y3\#2)  capacitor c=611.364a
    C362  (Y3\#2 Y2\#2317)  capacitor c=596.52a
    C402  (Y3\#2 10)  capacitor c=5.39839e-15
    C274  (Y3\#3 CK)  capacitor c=556.35a
    C275  (CK\#7 Y3\#3)  capacitor c=44.2514a
    C400  (Y3\#3 10)  capacitor c=3.2859e-15
    C405  (Y3\#3 net6)  capacitor c=83.616a
    C73  (vss\#8 Y3\#3)  capacitor c=185.47a
    C68  (Y3\#2316 vss)  capacitor c=6.0987e-18
    C326  (Y4\#2312 Y3\#2316)  capacitor c=564.044a
    C399  (Y3\#2316 10)  capacitor c=2.6075e-15
    C70  (Y3\#2311 vss)  capacitor c=9.3157e-18
    C71  (Y3\#2312 vss)  capacitor c=9.6027e-18
    C72  (Y3\#2313 vss)  capacitor c=3.44212e-18
    C245  (vdd\#2319 Y3\#2313)  capacitor c=67.3944a
    C361  (Y3\#2313 Y2\#2318)  capacitor c=242.596a
    C380  (net11\#2 Y2\#20)  capacitor c=83.616a
    C140  (Q\#3 net4)  capacitor c=41.34a
    C214  (QN\#4 net4)  capacitor c=83.616a
    C187  (net4\#2 SN\#8)  capacitor c=83.616a
    C433  (net4\#2 net3)  capacitor c=39.8112a
    C75  (Y3\#9 vss)  capacitor c=32.3431a
    C76  (Y3\#2315 vss)  capacitor c=3.29276e-19
    C323  (Y3\#9 Y4\#6)  capacitor c=1.66894e-19
    C325  (Y3\#2315 Y4\#6)  capacitor c=2.39915e-22
    C298  (CK\#7 net11\#2)  capacitor c=10.0521a
    C301  (CK\#7 net12\#2)  capacitor c=12.7571a
    C86  (vss\#5 net4)  capacitor c=72.6356a
    C87  (vss\#5 net4\#2)  capacitor c=73.7811a
    C142  (Q\#2310 X31_5)  capacitor c=507.204a
    C223  (Y4\#2310 vdd\#2315)  capacitor c=157.494a
    C240  (vdd\#2315 Y3\#2314)  capacitor c=236.315a
    C246  (Y3\#9 vdd\#2315)  capacitor c=23.657a
    C322  (Y3\#9 Y4\#2310)  capacitor c=205.299a
    C346  (Y4\#2310 X36_5)  capacitor c=501.364a
    C251  (vdd\#2315 X36_5)  capacitor c=182.829a
    C409  (Y3\#2314 X36_5)  capacitor c=511.921a
    C247  (Y3\#2315 vdd\#2315)  capacitor c=2.31801e-18
    C276  (Y3\#9 CK\#6)  capacitor c=844.145a
    C220  (vdd\#2317 CK\#6)  capacitor c=234.793a
    C242  (Y3\#2312 vdd\#2317)  capacitor c=204.098a
    C302  (CK\#6 X34_5)  capacitor c=531.824a
    C411  (Y3\#2312 X34_5)  capacitor c=148.996a
    C253  (vdd\#2317 X34_5)  capacitor c=148.996a
    C321  (Y3\#9 Y4\#5)  capacitor c=745.409a
    C324  (Y3\#2315 Y4\#5)  capacitor c=1.18505e-18
    C224  (vdd\#2316 Y4\#5)  capacitor c=234.633a
    C241  (vdd\#2316 Y3\#2311)  capacitor c=103.525a
    C347  (Y4\#5 X35_5)  capacitor c=510.168a
    C252  (vdd\#2316 X35_5)  capacitor c=162.469a
    C410  (Y3\#2311 X35_5)  capacitor c=188.398a
    C248  (vdd\#3 Y3\#2311)  capacitor c=52.1384a
    C249  (vdd\#3 10)  capacitor c=73.9846f
    C403  (Y3\#9 10)  capacitor c=12.0272f
    C404  (Y3\#2315 10)  capacitor c=351.461a
    C98  (10 D)  capacitor c=1.35022e-15
    C2  (vss\#1 D)  capacitor c=49.2015a
    C3  (vss\#1 D\#3)  capacitor c=135.282a
    C100  (D\#3 10)  capacitor c=1.48451e-15
    C69  (vss\#1 Y3\#5)  capacitor c=154.182a
    C401  (Y3\#5 10)  capacitor c=2.7738e-15
    C93  (vss\#1 net1)  capacitor c=73.0223a
    C102  (D\#3 net1)  capacitor c=83.616a
    C430  (net1 10)  capacitor c=251.403a
    C96  (Y4\#2312 D)  capacitor c=14.8452a
    C328  (Y4\#2312 Y3\#9)  capacitor c=522.335a
    C329  (Y4\#2312 Y3\#2315)  capacitor c=43.5407a
    C431  (net1\#2 10)  capacitor c=229.802a
    C226  (vdd\#2318 Y2\#2318)  capacitor c=234.793a
    C243  (Y3\#2313 vdd\#2318)  capacitor c=204.098a
    C254  (vdd\#2318 X33_5)  capacitor c=148.996a
    C381  (Y2\#2318 X33_5)  capacitor c=531.824a
    C412  (Y3\#2313 X33_5)  capacitor c=149.738a
    C408  (net1\#2 Y3\#2316)  capacitor c=83.616a
    C317  (Y4\#2313 Y3\#5)  capacitor c=56.3609a
    C344  (Y4\#2313 net1\#2)  capacitor c=59.8477a
    C319  (Y3\#6 Y4\#2313)  capacitor c=28.8482a
    C343  (net1\#2 Y4\#8)  capacitor c=1.12473e-18
    C318  (Y3\#6 Y4\#8)  capacitor c=104.251a
    C407  (net12\#2 Y3\#5)  capacitor c=1.372e-18
    C342  (Y4\#2312 net12\#2)  capacitor c=8.83213e-18
    C341  (Y4\#2312 net12)  capacitor c=17.4297a
    C340  (Y4\#8 net12)  capacitor c=87.3632a
    C406  (Y3\#6 net12)  capacitor c=55.7448a
    C77  (vss\#3 Y3\#6)  capacitor c=71.0785a
    C92  (vss\#3 net12\#2)  capacitor c=85.7666a
    C428  (net12 10)  capacitor c=546.443a
    C429  (net12\#2 10)  capacitor c=949.665a
    C91  (vss\#3 net11\#2)  capacitor c=105.129a
    C90  (vss\#3 net11)  capacitor c=72.6356a
    C426  (net11 10)  capacitor c=221.122a
    C427  (net11\#2 10)  capacitor c=221.343a
    C434  (net12\#2 net11)  capacitor c=46.0379a
    C295  (net11 CK)  capacitor c=62.9349a
    C297  (net11\#2 CK)  capacitor c=63.4452a
    C299  (net12\#2 CK)  capacitor c=160.388a
    C290  (net4 CK)  capacitor c=68.4719a
    C291  (net4\#2 CK)  capacitor c=68.4915a
    C422  (net4 10)  capacitor c=221.122a
    C423  (net4\#2 10)  capacitor c=221.343a
    C296  (CK\#8 net11)  capacitor c=83.616a
    C300  (net12\#2 CK\#8)  capacitor c=101.713a
    C112  (vdd\#21 Q\#9)  capacitor c=91.3a
    C117  (vdd\#8 Q\#9)  capacitor c=52.1384a
    C143  (Q\#9 X30_5)  capacitor c=169.256a
    C257  (vdd\#21 X30_5)  capacitor c=154.377a
    C219  (QN\#5 X30_5)  capacitor c=522.458a
    C192  (vdd\#21 QN\#5)  capacitor c=303.376a
    C114  (Q\#8 vdd\#23)  capacitor c=143.006a
    C131  (Q\#8 Y2\#2316)  capacitor c=141.206a
    C382  (Y2\#2316 X28_5)  capacitor c=480.556a
    C145  (Q\#8 X28_5)  capacitor c=318.488a
    C259  (vdd\#23 X28_5)  capacitor c=188.398a
    C113  (Q\#6 vdd\#22)  capacitor c=230.559a
    C144  (Q\#6 X29_5)  capacitor c=445.838a
    C146  (vdd\#22 SN\#6)  capacitor c=235.812a
    C188  (SN\#6 X29_5)  capacitor c=533.577a
    C258  (vdd\#22 X29_5)  capacitor c=188.398a
    C221  (vdd\#24 CK\#4)  capacitor c=234.793a
    C229  (vdd\#24 Y2\#2310)  capacitor c=151.96a
    C260  (vdd\#24 X27_5)  capacitor c=148.996a
    C303  (CK\#4 X27_5)  capacitor c=531.824a
    C383  (Y2\#2310 X27_5)  capacitor c=149.738a
    C231  (vdd\#25 Y2\#2311)  capacitor c=104.314a
    C235  (vdd\#25 Y1\#9)  capacitor c=234.633a
    C261  (vdd\#25 X26_5)  capacitor c=162.469a
    C384  (Y2\#2311 X26_5)  capacitor c=188.398a
    C393  (Y1\#9 X26_5)  capacitor c=533.577a
    C191  (QN\#8 vdd\#20)  capacitor c=182.858a
    C218  (QN\#8 X31_5)  capacitor c=509.303a
    C256  (vdd\#20 X31_5)  capacitor c=192.097a
    MX37_M0_unmatched  (Y4\#9 D\#4 vdd\#1 vdd\#1)  pch w=4e-06 l=1e-06 \
        as=0 ad=1e-11 ps=0 pd=1.3e-05 sa=2e-06 sb=2e-06
    MX23_M0_unmatched  (Y1\#6 SN\#4 vdd\#2314 vdd\#2314)  pch w=4e-06 \
        l=1e-06 as=0 ad=1e-11 ps=0 pd=1.3e-05 sa=2e-06 sb=2e-06
    MX25_M0_unmatched  (Y1\#7 Y2\#4 vdd\#26 vdd\#26)  pch w=4e-06 l=1e-06 \
        as=0 ad=1e-11 ps=0 pd=1.3e-05 sa=2e-06 sb=2e-06
    MX24_M0_unmatched  (Y1\#8 Y4\#4 vdd\#27 vdd\#27)  pch w=4e-06 l=1e-06 \
        as=0 ad=1e-11 ps=0 pd=1.3e-05 sa=2e-06 sb=2e-06
    MX32_M0_unmatched  (QN\#7 Y3\#4 vdd\#2319 vdd\#2319)  pch w=4e-06 \
        l=1e-06 as=0 ad=1e-11 ps=0 pd=1.3e-05 sa=2e-06 sb=2e-06
    MX31_M0_unmatched  (QN\#8 Q\#2310 vdd\#20 vdd\#20)  pch w=4e-06 \
        l=1e-06 as=0 ad=1e-11 ps=0 pd=1.3e-05 sa=2e-06 sb=2e-06
    MX36_M0_unmatched  (Y4\#2310 Y3\#2314 vdd\#2315 vdd\#2315)  pch \
        w=4e-06 l=1e-06 as=0 ad=1e-11 ps=0 pd=1.3e-05 sa=2e-06 sb=2e-06
    MX34_M0_unmatched  (Y3\#2312 CK\#6 vdd\#2317 vdd\#2317)  pch w=4e-06 \
        l=1e-06 as=0 ad=1e-11 ps=0 pd=1.3e-05 sa=2e-06 sb=2e-06
    MX35_M0_unmatched  (Y3\#2311 Y4\#5 vdd\#2316 vdd\#2316)  pch w=4e-06 \
        l=1e-06 as=0 ad=1e-11 ps=0 pd=1.3e-05 sa=2e-06 sb=2e-06
    MX33_M0_unmatched  (Y3\#2313 Y2\#2318 vdd\#2318 vdd\#2318)  pch \
        w=4e-06 l=1e-06 as=0 ad=1e-11 ps=0 pd=1.3e-05 sa=2e-06 sb=2e-06
    MX30_M0_unmatched  (Q\#9 QN\#5 vdd\#21 vdd\#21)  pch w=4e-06 l=1e-06 \
        as=0 ad=1e-11 ps=0 pd=1.3e-05 sa=2e-06 sb=2e-06
    MX28_M0_unmatched  (Q\#8 Y2\#2316 vdd\#23 vdd\#23)  pch w=4e-06 \
        l=1e-06 as=0 ad=1e-11 ps=0 pd=1.3e-05 sa=2e-06 sb=2e-06
    MX29_M0_unmatched  (Q\#6 SN\#6 vdd\#22 vdd\#22)  pch w=4e-06 l=1e-06 \
        as=0 ad=1e-11 ps=0 pd=1.3e-05 sa=2e-06 sb=2e-06
    MX27_M0_unmatched  (Y2\#2310 CK\#4 vdd\#24 vdd\#24)  pch w=4e-06 \
        l=1e-06 as=0 ad=1e-11 ps=0 pd=1.3e-05 sa=2e-06 sb=2e-06
    MX26_M0_unmatched  (Y2\#2311 Y1\#9 vdd\#25 vdd\#25)  pch w=4e-06 \
        l=1e-06 as=0 ad=1e-11 ps=0 pd=1.3e-05 sa=2e-06 sb=2e-06
    Rd26  (Y4\#2312 Y4\#2313)  resistor r=5.1795
    Rd36  (vdd\#7 vdd\#8)  resistor r=99.34m
    Rd49  (vdd\#5 vdd\#2319)  resistor r=4.4308
    Rc59  (vdd\#5 vdd\#7)  resistor r=167.8m
    Rd19  (CK\#7 CK)  resistor r=86.864
    Rd3  (Y4 Y4\#6)  resistor r=1080.0958
    Rd24  (Y4 Y4\#2312)  resistor r=2.5034
    Rc45  (Y4\#9 Y4\#2312)  resistor r=3.4611
    Rc41  (Y4\#6 Y4\#2312)  resistor r=93.0226
    Rs1  (10 vss)  resistor r=50
    Rd23  (D\#2 D\#4)  resistor r=1936.0317
    Rc42  (Y4\#9 Y4\#2310)  resistor r=19.1845
    Rd1  (Y4\#2310 Y4\#2312)  resistor r=3.3932
    Rd25  (Q\#2310 Q\#4)  resistor r=2323.2666
    Rc46  (Q\#4 Q)  resistor r=848.761
    Rc49  (Q\#2310 Q\#2311)  resistor r=3600
    Rd18  (Q Q\#3)  resistor r=554.3842
    Rc51  (Q\#4 Q\#3)  resistor r=90859.5312
    Rd10  (SN\#2 SN\#4)  resistor r=2536.0317
    Rc68  (SN\#2 SN)  resistor r=86.364
    Rd9  (SN\#6 SN\#7)  resistor r=2536.0317
    Rd8  (SN\#7 SN)  resistor r=85.664
    Rc90  (QN\#2 QN\#8)  resistor r=1668.4176
    Rc88  (QN\#2 QN\#3)  resistor r=535.853
    Rc89  (QN\#3 QN\#6)  resistor r=10.1
    Rc63  (vdd\#27 vdd\#2314)  resistor r=111.4963
    Rd37  (vdd\#2319 vdd\#7)  resistor r=6.6684
    Rd22  (CK\#6 CK\#7)  resistor r=3136.0317
    Rc8  (vss\#3 vss\#9)  resistor r=62.5645
    Rc23  (vss\#7 vss\#3)  resistor r=5.1603
    Rc55  (CK\#7 CK\#8)  resistor r=436.0318
    Rc40  (Y4\#6 Y4\#5)  resistor r=1936.0317
    Rd28  (Y4\#2 Y4\#3)  resistor r=1636.0317
    Rc43  (Y4\#2 Y4\#4)  resistor r=1936.0317
    Rc44  (Y4\#2 Y4)  resistor r=85.464
    Rd2  (Y4\#6 Y4\#8)  resistor r=1036.0317
    Rd11  (Y2 Y2\#2311)  resistor r=5.5331
    Rd44  (Y2\#2 Y2\#4)  resistor r=736.0318
    Rc65  (Y2\#3 Y2\#2)  resistor r=1959.2117
    Rc78  (Y2\#2 Y2)  resistor r=85.464
    Rd46  (Y2\#2313 Y2\#2315)  resistor r=2236.0317
    Rd31  (Y2\#2313 Y2\#2317)  resistor r=91.564
    Rd45  (Y2\#2314 Y2\#2316)  resistor r=736.0318
    Rc64  (Y2\#2313 Y2\#2314)  resistor r=572.0635
    Rd17  (Q\#4 Q\#5)  resistor r=5.1981
    Rd16  (Q\#5 Q\#6)  resistor r=3.1952
    Rd4  (Y2\#3 Y2\#5)  resistor r=781.9571
    Rc21  (Y1 Y1\#2)  resistor r=10.1
    Rd42  (Y1\#2311 Y1)  resistor r=614.2733
    Rc67  (Y2\#5 Y2\#6)  resistor r=5.1779
    Rc9  (vss vss\#5)  resistor r=266.3m
    Rc7  (vss\#3 vss\#5)  resistor r=0.401
    Rc6  (vss\#9 vss\#5)  resistor r=5.5851
    Rc54  (SN\#7 SN\#8)  resistor r=1036.0317
    Rc16  (net3 net3\#2)  resistor r=10.1
    Rc81  (QN\#4 QN\#5)  resistor r=3600
    Rc87  (QN\#4 QN\#3)  resistor r=1723.2665
    Rc82  (QN\#2 QN)  resistor r=5.1
    Rc83  (QN\#2 QN\#7)  resistor r=1701.7859
    Rc32  (net6 net6\#2)  resistor r=10.1
    Rc85  (QN\#7 QN\#8)  resistor r=5.0576
    Rc86  (vss\#5 vss\#2310)  resistor r=5.0974
    Rc69  (CK\#2 CK\#3)  resistor r=436.0318
    Rc10  (net9 net9\#2)  resistor r=10.1779
    Rd7  (CK\#2 CK\#4)  resistor r=3136.0317
    Rc70  (CK\#2 CK)  resistor r=85.564
    Rd43  (Y1\#2310 Y1\#2311)  resistor r=1172.0636
    Rc20  (Y1\#2311 Y1\#2312)  resistor r=436.0318
    Rd53  (Y1\#2310 Y1\#4)  resistor r=85.6621
    Rc2  (net7 net7\#2)  resistor r=10.1
    Rc79  (SN\#2 SN\#3)  resistor r=1036.0317
    Rc1  (net8 net8\#2)  resistor r=10.1
    Rc26  (vss vss\#6)  resistor r=5.1322
    Rc47  (Y1\#9 Y1\#2310)  resistor r=1336.0317
    Rd32  (Y2\#2314 Y2\#8)  resistor r=85.5621
    Rd33  (Y2\#8 Y2\#2310)  resistor r=2.6545
    Rc33  (Y2 Y2\#8)  resistor r=408.9m
    Rc4  (Y2\#8 Y2\#2311)  resistor r=5.4796
    Rc25  (Y1\#4 Y1\#6)  resistor r=3.3574
    Rd5  (vdd vdd\#2314)  resistor r=2.8204
    Rd51  (Y1\#8 Y1\#6)  resistor r=47.1422
    Rd52  (Y1\#4 Y1\#8)  resistor r=3.1338
    Rc22  (Y1\#4 Y1\#7)  resistor r=2.7545
    Rc71  (vdd vdd\#26)  resistor r=2.6083
    Rc77  (vdd vdd\#27)  resistor r=2.7535
    Rd14  (Y3\#2 Y3\#4)  resistor r=736.0318
    Rc80  (Y2\#2319 Y2\#2317)  resistor r=80.464
    Rd34  (Y2\#2319 Y2\#20)  resistor r=2236.0317
    Rc66  (Y2\#2318 Y2\#2319)  resistor r=1336.0317
    Rd15  (Y3\#2 Y3)  resistor r=85.464
    Rc14  (Y3\#2 Y3\#3)  resistor r=2836.0317
    Rc5  (vss\#3 vss\#8)  resistor r=5.0974
    Rc74  (vdd\#7 vdd\#20)  resistor r=2.6224
    Rc24  (vss\#1 vss\#7)  resistor r=869.3669
    Rd20  (vdd\#1 vdd\#2315)  resistor r=224.4252
    Rd38  (vdd\#1 vdd\#3)  resistor r=2.7962
    Rc56  (D\#2 D\#3)  resistor r=1036.0317
    Rd21  (D\#2 D)  resistor r=85.564
    Rc39  (Y3 Y3\#2313)  resistor r=4.0799
    Rc12  (Y3 Y3\#9)  resistor r=301.5m
    Rc48  (Q\#5 Q\#9)  resistor r=2.6545
    Rc50  (Q\#5 Q\#8)  resistor r=3.2591
    Rc76  (vdd vdd\#2311)  resistor r=99.84m
    Rc62  (vdd vdd\#25)  resistor r=3.9666
    Rd13  (Y3\#2315 Y3\#2314)  resistor r=736.0318
    Rc38  (Y3\#2315 Y3\#9)  resistor r=92.1887
    Rd27  (Y3\#9 Y3\#2312)  resistor r=2.6545
    Rd12  (Y3\#2315 Y3\#2311)  resistor r=1247.4707
    Rd30  (Y3\#2311 Y3\#9)  resistor r=2.8568
    Rc72  (vdd\#3 vdd\#2316)  resistor r=2.6224
    Rd40  (vdd\#3 vdd\#2317)  resistor r=5.3108
    Rd39  (vdd\#2317 vdd\#5)  resistor r=5.3108
    Rc57  (vdd\#2315 vdd\#3)  resistor r=2.6865
    Rc58  (vdd\#3 vdd\#5)  resistor r=133.7m
    Rc73  (vdd\#5 vdd\#2318)  resistor r=2.6224
    Rc52  (net1 net1\#2)  resistor r=10.1
    Rd29  (Y3\#9 Y3\#2313)  resistor r=8.1598
    Rc13  (Y3\#2316 Y3\#2315)  resistor r=2236.0317
    Rc11  (Y3\#2316 Y3\#5)  resistor r=476.9571
    Rc15  (Y3\#5 Y3\#6)  resistor r=10.1779
    Rc37  (net12 net12\#2)  resistor r=10.1779
    Rc3  (vss\#1 vss\#3)  resistor r=5.5725
    Rc34  (net11 net11\#2)  resistor r=10.1
    Rc19  (net4 net4\#2)  resistor r=10.1
    Rc60  (vdd\#8 vdd\#21)  resistor r=2.6224
    Rd41  (Q\#6 Q\#8)  resistor r=23.2112
    Rc61  (vdd\#2310 vdd\#23)  resistor r=2.6224
    Rc75  (vdd\#8 vdd\#2310)  resistor r=167.8m
    Rd35  (vdd\#8 vdd\#22)  resistor r=4.4308
    Rd47  (vdd\#22 vdd\#2310)  resistor r=6.6684
    Rd48  (vdd\#2310 vdd\#2311)  resistor r=66.01m
    Rd50  (vdd\#2311 vdd\#24)  resistor r=2.6224
    Rd6  (vdd\#2311 vdd\#25)  resistor r=7.9332
    MX40_M0_unmatched  (Y1\#2 Y2\#3 net7 net7)  nch w=2e-06 l=1e-06 as=0 \
        ad=5e-12 ps=0 pd=9e-06 sa=2e-06 sb=2e-06
    MX43_M0_unmatched  (net3\#2 Y2\#2315 vss\#9 vss\#9)  nch w=2e-06 \
        l=1e-06 as=0 ad=5e-12 ps=0 pd=9e-06 sa=2e-06 sb=2e-06
    MX46_M0_unmatched  (QN\#6 Q\#2311 net6\#2 net6\#2)  nch w=2e-06 l=1e-06 \
        as=0 ad=5e-12 ps=0 pd=9e-06 sa=2e-06 sb=2e-06
    MX42_M0_unmatched  (net9 CK\#3 vss\#2310 vss\#2310)  nch w=2e-06 \
        l=1e-06 as=0 ad=5e-12 ps=0 pd=9e-06 sa=2e-06 sb=2e-06
    MX41_M0_unmatched  (Y2\#6 Y1\#2312 net9\#2 net9\#2)  nch w=2e-06 l=1e-06 \
        as=0 ad=5e-12 ps=0 pd=9e-06 sa=2e-06 sb=2e-06
    MX39_M0_unmatched  (net7\#2 Y4\#3 net8 net8)  nch w=2e-06 l=1e-06 as=0 \
        ad=5e-12 ps=0 pd=9e-06 sa=2e-06 sb=2e-06
    MX38_M0_unmatched  (net8\#2 SN\#3 vss\#6 vss\#6)  nch w=2e-06 l=1e-06 \
        as=0 ad=5e-12 ps=0 pd=9e-06 sa=2e-06 sb=2e-06
    MX47_M0_unmatched  (net6 Y3\#3 vss\#8 vss\#8)  nch w=2e-06 l=1e-06 \
        as=0 ad=5e-12 ps=0 pd=9e-06 sa=2e-06 sb=2e-06
    MX48_M0_unmatched  (net11\#2 Y2\#20 vss\#7 vss\#7)  nch w=2e-06 \
        l=1e-06 as=0 ad=5e-12 ps=0 pd=9e-06 sa=2e-06 sb=2e-06
    MX45_M0_unmatched  (Q\#3 QN\#4 net4 net4)  nch w=2e-06 l=1e-06 as=0 \
        ad=5e-12 ps=0 pd=9e-06 sa=2e-06 sb=2e-06
    MX44_M0_unmatched  (net4\#2 SN\#8 net3 net3)  nch w=2e-06 l=1e-06 as=0 \
        ad=5e-12 ps=0 pd=9e-06 sa=2e-06 sb=2e-06
    MX52_M0_unmatched  (net1 D\#3 vss\#1 vss\#1)  nch w=2e-06 l=1e-06 as=0 \
        ad=5e-12 ps=0 pd=9e-06 sa=2e-06 sb=2e-06
    MX51_M0_unmatched  (Y4\#2313 Y3\#2316 net1\#2 net1\#2)  nch w=2e-06 \
        l=1e-06 as=0 ad=5e-12 ps=0 pd=9e-06 sa=2e-06 sb=2e-06
    MX50_M0_unmatched  (Y3\#6 Y4\#8 net12 net12)  nch w=2e-06 l=1e-06 as=0 \
        ad=5e-12 ps=0 pd=9e-06 sa=2e-06 sb=2e-06
    MX49_M0_unmatched  (net12\#2 CK\#8 net11 net11)  nch w=2e-06 l=1e-06 \
        as=0 ad=5e-12 ps=0 pd=9e-06 sa=2e-06 sb=2e-06
ends DFFSX1
