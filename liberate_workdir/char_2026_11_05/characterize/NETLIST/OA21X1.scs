// OA21X1
simulator lang=spectre insensitive=yes
global vss vdd
subckt OA21X1 A B C Y
    C1  (vdd\#1 vss)  capacitor c=33.2411a
    C18  (YN\#9 vss)  capacitor c=3.75903e-18
    C20  (5 vss)  capacitor c=13.4398f
    C28  (vdd\#1 Y\#2)  capacitor c=140.489a
    C30  (vdd\#1 YN\#9)  capacitor c=238.604a
    C33  (vdd\#1 5)  capacitor c=359.739a
    C75  (Y\#2 YN\#9)  capacitor c=260.136a
    C79  (Y\#2 5)  capacitor c=1.06632e-15
    C96  (YN\#9 5)  capacitor c=1.25461e-15
    C2  (A vss)  capacitor c=7.9093e-18
    C52  (5 A)  capacitor c=939.514a
    C3  (A\#4 vss)  capacitor c=5.75886e-18
    C44  (Y\#2 A\#4)  capacitor c=4.49653e-18
    C53  (A\#4 5)  capacitor c=2.04751e-15
    C4  (A\#3 vss)  capacitor c=11.624a
    C54  (A\#3 5)  capacitor c=1.41954e-15
    C5  (A\#2 vss)  capacitor c=12.4454a
    C55  (A\#2 5)  capacitor c=5.00228e-15
    C6  (C vss)  capacitor c=6.13667e-18
    C67  (5 C)  capacitor c=5.93433e-15
    C7  (C\#2 vss)  capacitor c=5.24461e-18
    C68  (C\#2 5)  capacitor c=2.0284e-15
    C8  (vss\#2 C)  capacitor c=13.617a
    C22  (vss\#2 5)  capacitor c=7.43977e-15
    C9  (vss\#2 C\#4)  capacitor c=126.301a
    C69  (C\#4 5)  capacitor c=1.47218e-15
    C10  (C\#3 vss\#2)  capacitor c=9.82844e-19
    C70  (C\#3 5)  capacitor c=330.953a
    C11  (Y vss)  capacitor c=5.80631e-18
    C43  (Y A)  capacitor c=7.77555e-18
    C46  (A\#2 Y)  capacitor c=8.05363e-18
    C51  (YN\#2 A\#2)  capacitor c=638.594a
    C65  (YN\#2 C)  capacitor c=32.3055a
    C66  (YN\#2 C\#3)  capacitor c=1.11276e-18
    C78  (5 Y)  capacitor c=2.53057e-15
    C13  (B vss)  capacitor c=12.9263a
    C60  (B C)  capacitor c=25.1522a
    C62  (B\#3 C)  capacitor c=4.73762e-19
    C16  (B\#3 vss)  capacitor c=7.37463e-19
    C61  (C\#3 B)  capacitor c=1.59421e-18
    C63  (B\#3 C\#3)  capacitor c=3.00281e-20
    C84  (YN\#2 B)  capacitor c=971.921a
    C85  (YN\#2 B\#3)  capacitor c=56.2141a
    C86  (5 B)  capacitor c=5.29848e-15
    C89  (B\#3 5)  capacitor c=301.166a
    C91  (net2\#2 B)  capacitor c=54.112a
    C93  (B\#3 net2\#2)  capacitor c=3.42975e-18
    C109  (net2\#2 5)  capacitor c=2.20951e-15
    C14  (B\#2 vss)  capacitor c=4.93082e-18
    C87  (B\#2 5)  capacitor c=2.5782e-15
    C15  (B\#4 vss)  capacitor c=7.14554e-18
    C88  (B\#4 5)  capacitor c=762.204a
    C92  (net2\#2 B\#4)  capacitor c=184.144a
    C17  (YN vss)  capacitor c=41.2376a
    C47  (YN A)  capacitor c=81.1723a
    C73  (YN Y)  capacitor c=378.726a
    C45  (Y\#1 A)  capacitor c=11.9801a
    C74  (Y\#2 YN)  capacitor c=17.3182a
    C81  (Y\#2 X7_5)  capacitor c=450.085a
    C40  (vdd\#1 X7_5)  capacitor c=175.347a
    C29  (B\#2 vdd)  capacitor c=63.5259a
    C32  (5 vdd)  capacitor c=12.2636f
    C39  (X7_5 vdd)  capacitor c=30.6619a
    C103  (YN\#9 X7_5)  capacitor c=508.67a
    C76  (Y\#1 YN)  capacitor c=16.9161a
    C80  (Y\#1 5)  capacitor c=1.48395e-15
    C95  (5 YN)  capacitor c=12.6984f
    C98  (YN\#9 net1)  capacitor c=1.87456e-18
    C36  (net1 vdd)  capacitor c=68.6095a
    C48  (YN\#2311 A)  capacitor c=7.13252e-18
    C57  (net2 A)  capacitor c=32.8495a
    C24  (net2 vss)  capacitor c=375.6a
    C56  (A\#4 net1)  capacitor c=139.36a
    C58  (A\#3 net2)  capacitor c=181.404a
    C77  (Y\#1 YN\#2311)  capacitor c=224.754a
    C97  (YN\#2311 5)  capacitor c=2.11453e-15
    C100  (YN\#2 net1)  capacitor c=5.52053e-18
    C106  (net1 5)  capacitor c=78.8258a
    C108  (net2 5)  capacitor c=1.99549e-15
    C12  (vss\#1 Y\#1)  capacitor c=71.7835a
    C19  (vss\#1 YN\#2311)  capacitor c=135.116a
    C21  (vss\#1 5)  capacitor c=1.1911e-15
    C23  (net1\#2 vss)  capacitor c=1.87456e-18
    C38  (net1\#2 vdd)  capacitor c=76.8672a
    C90  (net1\#2 B\#2)  capacitor c=139.36a
    C107  (net1\#2 5)  capacitor c=79.2239a
    C25  (vss\#2 net2\#4)  capacitor c=100.122a
    C71  (net2\#4 C\#4)  capacitor c=84.7237a
    C110  (net2\#4 5)  capacitor c=251.655a
    C26  (vdd\#3 A\#4)  capacitor c=235.79a
    C34  (vdd\#3 5)  capacitor c=44.6689a
    C35  (vdd\#2 5)  capacitor c=6.76432e-15
    C27  (vdd\#2 C\#2)  capacitor c=239.793a
    C37  (vdd\#3 net1)  capacitor c=75.9625a
    C41  (vdd\#3 X6_5)  capacitor c=183.465a
    C111  (X6_5 net1)  capacitor c=318.488a
    C59  (A\#4 X6_5)  capacitor c=528.626a
    C50  (YN\#3 A\#4)  capacitor c=5.57746e-18
    C82  (YN\#3 B\#2)  capacitor c=388.786a
    C99  (YN\#3 net1\#2)  capacitor c=96.3644a
    C94  (B\#2 X5_5)  capacitor c=505.217a
    C112  (net1\#2 X5_5)  capacitor c=318.488a
    C104  (YN\#3 X5_5)  capacitor c=502.728a
    C31  (YN\#5 vdd\#2)  capacitor c=212.138a
    C64  (YN\#5 C\#2)  capacitor c=154.672a
    C42  (vdd\#2 X4_5)  capacitor c=480.747a
    C72  (C\#2 X4_5)  capacitor c=503.077a
    C105  (YN\#5 X4_5)  capacitor c=319.404a
    C49  (YN\#8 A\#3)  capacitor c=90.6085a
    C101  (YN\#8 net2)  capacitor c=100.266a
    C83  (YN\#6 B\#4)  capacitor c=104.384a
    C102  (YN\#6 net2\#2)  capacitor c=119.21a
    MX11_M0_unmatched  (Y\#1 YN\#2311 vss\#1 vss\#1)  nch w=2e-06 l=1e-06 \
        as=0 ad=5e-12 ps=0 pd=9e-06 sa=2e-06 sb=2e-06
    MX8_M0_unmatched  (net2\#4 C\#4 vss\#2 vss\#2)  nch w=2e-06 l=1e-06 \
        as=0 ad=5e-12 ps=0 pd=9e-06 sa=2e-06 sb=2e-06
    MX10_M0_unmatched  (YN\#8 A\#3 net2 net2)  nch w=2e-06 l=1e-06 as=0 \
        ad=5e-12 ps=0 pd=9e-06 sa=2e-06 sb=2e-06
    MX9_M0_unmatched  (YN\#6 B\#4 net2\#2 net2\#2)  nch w=2e-06 l=1e-06 as=0 \
        ad=5e-12 ps=0 pd=9e-06 sa=2e-06 sb=2e-06
    Rs1  (5 vss)  resistor r=50
    Rd10  (A\#2 A\#4)  resistor r=1936.0317
    Rd12  (A\#2 A)  resistor r=85.564
    Rc8  (A\#2 A\#3)  resistor r=1036.0317
    Rc21  (vss vss\#2)  resistor r=5.3655
    Rd11  (C\#3 C\#4)  resistor r=1036.0317
    Rc13  (C\#2 C\#3)  resistor r=1936.0317
    Rc10  (C\#3 C)  resistor r=85.564
    Rc16  (Y Y\#2)  resistor r=2.775
    Rd8  (B\#3 B)  resistor r=85.564
    Rd9  (B\#2 B\#3)  resistor r=2536.0317
    Rc9  (B\#3 B\#4)  resistor r=436.0318
    Rc15  (Y Y\#1)  resistor r=5.3
    Rc17  (vdd\#1 vdd)  resistor r=2.6632
    Rc4  (YN YN\#2)  resistor r=5.2981
    Rd3  (YN\#2310 YN)  resistor r=80.464
    Rd1  (YN\#9 YN\#2310)  resistor r=1336.0317
    Rc11  (YN\#2310 YN\#2311)  resistor r=1636.0317
    Rc12  (net2 net2\#2)  resistor r=15.8048
    Rc20  (vss\#1 vss)  resistor r=5.2382
    Rc3  (net1 net1\#2)  resistor r=5.05
    Rd7  (net2 net2\#4)  resistor r=16.1209
    Rc14  (net2\#2 net2\#4)  resistor r=14.7739
    Rc19  (vdd vdd\#3)  resistor r=2.6083
    Rc18  (vdd vdd\#2)  resistor r=2.7905
    Rd2  (YN\#2 YN\#3)  resistor r=3.1952
    Rd4  (YN\#3 YN\#5)  resistor r=23.2112
    Rc1  (YN\#2 YN\#5)  resistor r=3.2591
    Rc2  (YN\#2 YN\#8)  resistor r=5.6647
    Rd6  (YN\#2 YN\#6)  resistor r=5.5536
    Rc5  (YN\#8 YN\#6)  resistor r=101.3195
    MX7_M0_unmatched  (Y\#2 YN\#9 vdd\#1 vdd\#1)  pch w=4e-06 l=1e-06 as=0 \
        ad=1e-11 ps=0 pd=1.3e-05 sa=2e-06 sb=2e-06
    MX6_M0_unmatched  (net1 A\#4 vdd\#3 vdd\#3)  pch w=4e-06 l=1e-06 as=0 \
        ad=1e-11 ps=0 pd=1.3e-05 sa=2e-06 sb=2e-06
    MX5_M0_unmatched  (YN\#3 B\#2 net1\#2 net1\#2)  pch w=4e-06 l=1e-06 as=0 \
        ad=1e-11 ps=0 pd=1.3e-05 sa=2e-06 sb=2e-06
    MX4_M0_unmatched  (YN\#5 C\#2 vdd\#2 vdd\#2)  pch w=4e-06 l=1e-06 as=0 \
        ad=1e-11 ps=0 pd=1.3e-05 sa=2e-06 sb=2e-06
ends OA21X1
