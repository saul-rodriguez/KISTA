// Generated for: spectre
// Generated on: Oct 31 20:48:44 2022
// Design library name: KISTA_SOI_STDLIB2
// Design cell name: timing
// Design view name: schematic
simulator lang=spectre
global 0 VSS! VDD!

// Library name: KISTA_SOI_STDLIB2
// Cell name: AOI21X1
// View name: analog_extracted
subckt AOI21X1_analog_extracted Y A C B
    C2 (Y\#1 A\#2) capacitor c=329.407a
    C17 (Y\#1 net3) capacitor c=87.8851a
    C22 (A\#2 VSS!) capacitor c=9.08949e-18
    C31 (A\#2 4) capacitor c=1.96915e-15
    C37 (A\#2 net3) capacitor c=172.304a
    C56 (4 VSS!) capacitor c=7.80613e-15
    C80 (net3 4) capacitor c=294.735a
    C8 (Y\#3 VSS!) capacitor c=177.764a
    C10 (Y\#1 VDD!) capacitor c=15.648a
    C25 (A\#2 VDD!) capacitor c=11.0323a
    C63 (4 VDD!) capacitor c=14.9937f
    C12 (Y\#3 B\#3) capacitor c=104.384a
    C54 (B\#3 VSS!) capacitor c=66.9675a
    C71 (B\#3 4) capacitor c=755.358a
    C15 (Y\#2 4) capacitor c=9.14425e-15
    C6 (Y\#2 C) capacitor c=49.205a
    C39 (VSS! C) capacitor c=16.4444a
    C45 (4 C) capacitor c=5.911e-15
    C7 (Y\#2 C\#3) capacitor c=2.34265e-18
    C48 (C\#3 4) capacitor c=329.706a
    C41 (VSS!\#2 C) capacitor c=12.7168a
    C43 (C\#3 VSS!\#2) capacitor c=1.54061e-18
    C58 (VSS!\#2 4) capacitor c=471.118a
    C9 (Y\#5 VSS!\#2) capacitor c=38.314a
    C5 (Y\#5 C\#4) capacitor c=92.1915a
    C42 (VSS!\#2 C\#4) capacitor c=187.466a
    C47 (C\#4 4) capacitor c=1.46591e-15
    C40 (C\#2 VSS!) capacitor c=2.45544e-18
    C46 (C\#2 4) capacitor c=2.06525e-15
    C4 (Y\#6 C\#2) capacitor c=19.9912a
    C11 (Y\#6 B\#4) capacitor c=399.334a
    C53 (B\#4 VSS!) capacitor c=15.8639a
    C70 (B\#4 4) capacitor c=2.5953e-15
    C13 (Y\#2 B) capacitor c=155.265a
    C52 (B VSS!) capacitor c=3.12695e-18
    C69 (4 B) capacitor c=861.277a
    C14 (Y\#2 B\#2) capacitor c=802.285a
    C55 (B\#2 VSS!) capacitor c=9.56655e-18
    C72 (B\#2 4) capacitor c=4.5348e-15
    C19 (Y\#1 X8_5) capacitor c=448.721a
    C38 (A\#2 X8_5) capacitor c=509.926a
    C83 (X8_5 net3) capacitor c=175.347a
    C3 (A\#3 Y) capacitor c=43.4332a
    C1 (A Y) capacitor c=685.256a
    C21 (VSS! A) capacitor c=3.55776e-18
    C24 (A\#3 VSS!) capacitor c=2.25499e-19
    C26 (B A) capacitor c=118.548a
    C27 (B\#2 A) capacitor c=30.166a
    C28 (A\#3 B) capacitor c=4.89247e-18
    C73 (net2\#2 B) capacitor c=46.4454a
    C16 (Y\#3 net2\#2) capacitor c=51.7222a
    C29 (A\#3 B\#2) capacitor c=4.33054e-20
    C30 (4 A) capacitor c=5.59823e-15
    C33 (A\#3 4) capacitor c=316.778a
    C60 (net2\#2 VSS!) capacitor c=1.12473e-18
    C74 (net2\#2 B\#3) capacitor c=83.616a
    C75 (B\#2 net2\#2) capacitor c=16.0906a
    C79 (net2\#2 4) capacitor c=237.325a
    C34 (net2 A) capacitor c=46.786a
    C36 (A\#3 net2) capacitor c=1.09427e-19
    C32 (A\#4 4) capacitor c=1.37305e-15
    C35 (A\#4 net2) capacitor c=83.616a
    C78 (net2 4) capacitor c=236.17a
    C61 (net2\#2 VSS!\#1) capacitor c=62.2561a
    C23 (VSS!\#1 A\#4) capacitor c=186.354a
    C59 (VSS!\#1 net2) capacitor c=103.983a
    C57 (VSS!\#1 4) capacitor c=7.15181e-15
    C18 (net3\#4 Y\#6) capacitor c=184.627a
    C62 (net3\#4 VSS!) capacitor c=14.7665a
    C51 (VDD!\#1 VSS!) capacitor c=11.2154a
    C44 (VDD!\#1 C\#2) capacitor c=182.208a
    C64 (VDD!\#1 4) capacitor c=531.697a
    C65 (net3\#4 VDD!) capacitor c=335.449a
    C76 (net3\#4 B\#4) capacitor c=240.232a
    C81 (net3\#4 4) capacitor c=2.46742e-15
    C82 (net3\#3 4) capacitor c=1.17642e-15
    C49 (net3\#3 C\#2) capacitor c=168.558a
    C66 (net3\#3 VDD!\#1) capacitor c=124.917a
    C67 (X6_5 VDD!) capacitor c=36.7943a
    C50 (C\#2 X6_5) capacitor c=532.553a
    C68 (VDD!\#1 X6_5) capacitor c=405.588a
    C85 (net3\#3 X6_5) capacitor c=149.036a
    C20 (Y\#6 X7_5) capacitor c=226.143a
    C77 (B\#4 X7_5) capacitor c=510.168a
    C84 (net3\#4 X7_5) capacitor c=162.469a
    MX8_M0_unmatched (Y\#1 A\#2 net3 net3) pch w=4e-06 l=1e-06 as=0 \
        ad=1e-11 ps=0 pd=1.3e-05 sa=2e-06 sb=2e-06
    MX6_M0_unmatched (net3\#3 C\#2 VDD!\#1 VDD!\#1) pch w=4e-06 l=1e-06 \
        as=0 ad=1e-11 ps=0 pd=1.3e-05 sa=2e-06 sb=2e-06
    MX7_M0_unmatched (Y\#6 B\#4 net3\#4 net3\#4) pch w=4e-06 l=1e-06 as=0 \
        ad=1e-11 ps=0 pd=1.3e-05 sa=2e-06 sb=2e-06
    Rs1 (4 VSS!) resistor r=50
    Rc1 (Y\#2 Y\#3) resistor r=5.5903
    Rc12 (C\#3 C) resistor r=85.564
    Rc15 (VSS! VSS!\#2) resistor r=5.0972
    Rd4 (Y\#2 Y\#5) resistor r=5.7021
    Rc2 (Y\#3 Y\#5) resistor r=95.6457
    Rd8 (C\#3 C\#4) resistor r=1036.0317
    Rc9 (C\#2 C\#3) resistor r=1936.0317
    Rd5 (Y\#2 Y\#6) resistor r=2.7731
    Rc6 (Y Y\#2) resistor r=179.5m
    Rd1 (B\#2 B\#4) resistor r=2536.0317
    Rd3 (B\#2 B) resistor r=85.564
    Rd6 (Y\#1 Y) resistor r=2.8529
    Rd7 (A\#2 A\#3) resistor r=1936.0317
    Rc13 (B\#2 B\#3) resistor r=436.0318
    Rd9 (A\#3 A) resistor r=85.564
    Rc8 (A\#3 A\#4) resistor r=1036.0317
    Rc7 (net2 net2\#2) resistor r=10.1
    Rc14 (VSS!\#1 VSS!) resistor r=5.2715
    Rd2 (net3 net3\#3) resistor r=8.4068
    Rc11 (net3 net3\#4) resistor r=7.8171
    Rc16 (VDD!\#1 VDD!) resistor r=2.7104
    Rc10 (net3\#4 net3\#3) resistor r=8.1065
    MX3_M0_unmatched (Y\#5 C\#4 VSS!\#2 VSS!\#2) nch w=2e-06 l=1e-06 as=0 \
        ad=5e-12 ps=0 pd=9e-06 sa=2e-06 sb=2e-06
    MX4_M0_unmatched (Y\#3 B\#3 net2\#2 net2\#2) nch w=2e-06 l=1e-06 as=0 \
        ad=5e-12 ps=0 pd=9e-06 sa=2e-06 sb=2e-06
    MX5_M0_unmatched (net2 A\#4 VSS!\#1 VSS!\#1) nch w=2e-06 l=1e-06 as=0 \
        ad=5e-12 ps=0 pd=9e-06 sa=2e-06 sb=2e-06
ends AOI21X1_analog_extracted
// End of subcircuit definition.

// Library name: KISTA_SOI_STDLIB2
// Cell name: BUFX2
// View name: analog_extracted
subckt BUFX2_analog_extracted A Y
    C20 (VDD!\#1 Y\#2) capacitor c=208.188a
    C22 (VDD!\#1 YN\#5) capacitor c=332.801a
    C27 (VDD!\#1 3) capacitor c=5.75028e-15
    C46 (Y\#2 YN\#5) capacitor c=365.175a
    C53 (Y\#2 3) capacitor c=865.928a
    C57 (YN\#5 3) capacitor c=1.25259e-15
    C6 (Y\#2 VSS!) capacitor c=5.40698e-18
    C9 (YN\#5 VSS!) capacitor c=1.99516e-18
    C16 (3 VSS!) capacitor c=4.4918e-15
    C1 (VDD!\#2 VSS!) capacitor c=10.4024a
    C28 (VDD!\#2 3) capacitor c=110.87a
    C2 (A VSS!) capacitor c=16.1666a
    C39 (3 A) capacitor c=6.27042e-15
    C3 (A\#2 VSS!) capacitor c=1.88065e-18
    C19 (VDD!\#2 A\#2) capacitor c=246.937a
    C40 (A\#2 3) capacitor c=1.26397e-15
    C5 (A\#3 VSS!) capacitor c=7.83915e-19
    C42 (A\#3 3) capacitor c=351.629a
    C8 (YN VSS!) capacitor c=2.99034e-18
    C21 (VDD!\#1 YN) capacitor c=11.2002a
    C45 (Y\#2 YN) capacitor c=16.9501a
    C56 (3 YN) capacitor c=4.89814e-15
    C10 (VSS!\#1 YN) capacitor c=9.52504e-18
    C17 (VSS!\#1 3) capacitor c=5.96683e-15
    C7 (VSS!\#1 Y\#1) capacitor c=145.046a
    C47 (Y\#1 YN) capacitor c=16.9161a
    C54 (Y\#1 3) capacitor c=1.27298e-15
    C11 (VSS!\#1 YN\#7) capacitor c=240.393a
    C48 (Y\#1 YN\#7) capacitor c=257.224a
    C58 (YN\#7 3) capacitor c=1.75591e-15
    C14 (YN\#3 VSS!\#1) capacitor c=70.6303a
    C13 (YN\#3 VSS!) capacitor c=50.3617a
    C51 (YN\#3 Y\#1) capacitor c=9.12421e-18
    C60 (YN\#3 3) capacitor c=1.12046e-15
    C61 (YN\#5 X3_5) capacitor c=508.173a
    C29 (VDD!\#1 X3_5) capacitor c=212.366a
    C55 (Y\#2 X3_5) capacitor c=604.97a
    C12 (YN\#4 VSS!) capacitor c=5.98191e-18
    C15 (VSS!\#2 YN\#3) capacitor c=44.4275a
    C18 (VSS!\#2 3) capacitor c=353.748a
    C24 (YN\#4 VDD!\#1) capacitor c=126.664a
    C23 (YN\#4 VDD!) capacitor c=50.3617a
    C25 (VDD!\#2 YN\#4) capacitor c=78.277a
    C26 (3 VDD!) capacitor c=4.46154e-15
    C35 (YN\#4 A) capacitor c=505.13a
    C32 (Y A) capacitor c=4.12265e-18
    C34 (A\#3 Y) capacitor c=2.61303e-19
    C36 (YN\#4 A\#2) capacitor c=258.025a
    C38 (A\#3 YN\#4) capacitor c=28.5625a
    C4 (VSS!\#2 A\#4) capacitor c=191.278a
    C33 (Y\#1 A\#4) capacitor c=3.9943e-18
    C37 (YN\#3 A\#4) capacitor c=307.472a
    C41 (A\#4 3) capacitor c=2.79279e-15
    C44 (YN Y) capacitor c=336.033a
    C49 (YN\#4 Y) capacitor c=18.8536a
    C50 (YN\#4 Y\#2) capacitor c=13.6817a
    C52 (3 Y) capacitor c=2.06304e-15
    C59 (YN\#4 3) capacitor c=4.03077e-15
    C30 (X2_5 VDD!) capacitor c=30.6619a
    C31 (VDD!\#2 X2_5) capacitor c=406.72a
    C43 (A\#2 X2_5) capacitor c=531.582a
    C62 (YN\#4 X2_5) capacitor c=175.629a
    MX3_M0_unmatched (Y\#2 YN\#5 VDD!\#1 VDD!\#1) pch w=8e-06 l=1e-06 as=0 \
        ad=2e-11 ps=0 pd=2.1e-05 sa=2e-06 sb=2e-06
    MX2_M0_unmatched (YN\#4 A\#2 VDD!\#2 VDD!\#2) pch w=4e-06 l=1e-06 as=0 \
        ad=1e-11 ps=0 pd=1.3e-05 sa=2e-06 sb=2e-06
    Rs1 (3 VSS!) resistor r=50
    Rd1 (A\#2 A\#3) resistor r=1336.0317
    Rd3 (A\#3 A) resistor r=85.564
    Rc9 (VSS!\#1 VSS!) resistor r=2.6965
    Rc2 (YN\#6 YN\#7) resistor r=1336.0317
    Rd4 (YN\#5 YN\#6) resistor r=1336.0317
    Rd6 (YN\#6 YN) resistor r=80.464
    Rd5 (YN YN\#3) resistor r=19.7445
    Rc10 (VSS! VSS!\#2) resistor r=5.0972
    Rc7 (VDD!\#1 VDD!) resistor r=1.4965
    Rc1 (A\#3 A\#4) resistor r=2236.0317
    Rc5 (Y Y\#1) resistor r=2.775
    Rc3 (YN\#4 YN\#3) resistor r=11.1679
    Rc4 (YN YN\#4) resistor r=10.7072
    Rc6 (Y Y\#2) resistor r=1.575
    Rc8 (VDD! VDD!\#2) resistor r=2.6222
    MX5_M0_unmatched (Y\#1 YN\#7 VSS!\#1 VSS!\#1) nch w=4e-06 l=1e-06 as=0 \
        ad=1e-11 ps=0 pd=1.3e-05 sa=2e-06 sb=2e-06
    MX4_M0_unmatched (YN\#3 A\#4 VSS!\#2 VSS!\#2) nch w=2e-06 l=1e-06 as=0 \
        ad=5e-12 ps=0 pd=9e-06 sa=2e-06 sb=2e-06
ends BUFX2_analog_extracted
// End of subcircuit definition.

// Library name: KISTA_SOI_STDLIB2
// Cell name: DFFSRX1
// View name: analog_extracted
subckt DFFSRX1_analog_extracted D Q SN QN RN CK
    C22 (RN\#2 VSS!) capacitor c=10.3983a
    C276 (RN\#2 13) capacitor c=1.92504e-15
    C33 (VSS!\#2 CK\#6) capacitor c=66.411a
    C380 (CK\#6 13) capacitor c=776.18a
    C317 (VDD!\#4 Y3\#6) capacitor c=37.5839a
    C15 (SN\#6 VSS!) capacitor c=7.29998e-19
    C32 (CK\#2 VSS!) capacitor c=5.9e-18
    C34 (VSS!\#2 CK\#5) capacitor c=209.25a
    C35 (VSS!\#4 CK) capacitor c=115.296a
    C40 (RNi\#2312 VSS!) capacitor c=10.8151a
    C41 (RNi\#2311 VSS!) capacitor c=86.3749a
    C46 (RNi\#5 VSS!) capacitor c=2.981e-18
    C54 (Y4\#8 VSS!) capacitor c=55.4545a
    C55 (Y4\#2312 VSS!) capacitor c=7.97704e-18
    C59 (Y4\#2 VSS!) capacitor c=2.33591e-18
    C70 (Y2\#2317 VSS!) capacitor c=16.3148a
    C85 (VSS!\#4 13) capacitor c=129.678f
    C182 (SN\#6 CK) capacitor c=308.055a
    C185 (CK\#2 SN\#6) capacitor c=3.45997e-20
    C191 (SN\#6 RNi\#3) capacitor c=650.544a
    C193 (RNi\#5 SN\#6) capacitor c=1.06807e-20
    C222 (SN\#6 13) capacitor c=5.82465e-15
    C284 (VDD!\#1 RNi\#2312) capacitor c=150.299a
    C290 (Y4\#2312 VDD!\#1) capacitor c=88.5389a
    C347 (RNi\#2311 CK) capacitor c=27.2181a
    C348 (RNi\#2311 CK\#5) capacitor c=761.554a
    C351 (CK\#2 RNi\#3) capacitor c=607.941a
    C352 (RNi\#5 CK) capacitor c=1.06046e-19
    C353 (RNi\#5 CK\#2) capacitor c=5.14917e-18
    C382 (CK\#5 13) capacitor c=35.4512f
    C383 (CK\#2 13) capacitor c=5.89787e-15
    C427 (RNi\#2311 Y4\#8) capacitor c=1.68054e-15
    C428 (RNi\#3 Y4\#8) capacitor c=733.745a
    C429 (Y4\#2312 RNi\#2312) capacitor c=664.727a
    C431 (Y4\#2 RNi\#3) capacitor c=30.9075a
    C432 (RNi\#5 Y4\#8) capacitor c=253.305a
    C433 (RNi\#5 Y4\#2) capacitor c=10.67a
    C442 (RNi\#2311 Y2\#2317) capacitor c=1.63206e-15
    C446 (RNi\#3 Y2\#2317) capacitor c=802.729a
    C449 (RNi\#5 Y2\#2317) capacitor c=11.1405a
    C461 (RNi\#2312 13) capacitor c=2.39827e-15
    C467 (RNi\#2311 13) capacitor c=49.4757f
    C468 (RNi\#5 13) capacitor c=5.76825e-15
    C493 (Y2\#2317 Y4\#8) capacitor c=3.91366e-15
    C516 (Y4\#8 13) capacitor c=55.4148f
    C553 (Y2\#2317 13) capacitor c=33.1577f
    C1 (D VSS!) capacitor c=19.9141a
    C114 (RNi\#2311 D) capacitor c=55.6601a
    C122 (13 D) capacitor c=1.52503e-15
    C2 (D\#2 VSS!) capacitor c=5.71744e-19
    C113 (D\#2 RNi\#2312) capacitor c=33.9973a
    C123 (D\#2 13) capacitor c=1.06759e-15
    C4 (D\#3 VSS!) capacitor c=5.31018e-18
    C115 (D\#3 RNi\#2311) capacitor c=571.177a
    C125 (D\#3 13) capacitor c=5.79577e-15
    C5 (Q VSS!) capacitor c=21.1936a
    C145 (CK Q) capacitor c=623.077a
    C148 (CK\#2 Q) capacitor c=19.1482a
    C150 (RNi\#2311 Q) capacitor c=1.1553e-15
    C156 (Y2\#2317 Q) capacitor c=484.263a
    C6 (Q\#2310 VSS!) capacitor c=7.36429e-18
    C163 (Q\#2310 13) capacitor c=177.251a
    C7 (Q\#2311 VSS!) capacitor c=1.32412e-18
    C155 (Q\#2311 Y4\#8) capacitor c=588.712a
    C161 (Q\#2311 Y2\#2317) capacitor c=543.205a
    C166 (Q\#2311 13) capacitor c=5.79806e-15
    C8 (VSS!\#2 Q\#2312) capacitor c=61.6419a
    C146 (CK\#5 Q\#2312) capacitor c=599.412a
    C151 (RNi\#2311 Q\#2312) capacitor c=609.757a
    C164 (Q\#2312 13) capacitor c=4.28371e-15
    C9 (VSS!\#4 Q\#3) capacitor c=156.13a
    C147 (Q\#3 CK) capacitor c=617.924a
    C10 (SN\#7 VSS!) capacitor c=12.4308a
    C197 (Y4\#8 SN\#7) capacitor c=10.3472a
    C200 (Y4\#2 SN\#7) capacitor c=4.35853e-19
    C215 (SN\#7 13) capacitor c=3.05409e-15
    C11 (SN\#1 VSS!) capacitor c=14.2235a
    C216 (SN\#1 13) capacitor c=1.28298e-15
    C12 (SN\#4 VSS!) capacitor c=62.8601a
    C180 (SN\#4 CK) capacitor c=576.195a
    C219 (SN\#4 13) capacitor c=1.99514e-15
    C13 (SN\#9 VSS!) capacitor c=25.7229a
    C181 (SN\#9 CK) capacitor c=1.95035e-15
    C184 (CK\#2 SN\#9) capacitor c=621.277a
    C192 (RNi\#5 SN\#9) capacitor c=611.509a
    C209 (SN\#9 Y2\#2317) capacitor c=814.835a
    C220 (SN\#9 13) capacitor c=26.3378f
    C16 (VSS!\#4 SN\#2310) capacitor c=61.2785a
    C178 (SN\#2310 CK) capacitor c=278.279a
    C183 (CK\#2 SN\#2310) capacitor c=4.29376e-18
    C217 (SN\#2310 13) capacitor c=1.3606e-15
    C17 (QN\#5 VSS!) capacitor c=3.19218e-18
    C246 (Y4\#8 QN\#5) capacitor c=589.783a
    C250 (Y2\#2317 QN\#5) capacitor c=544.041a
    C259 (QN\#5 13) capacitor c=4.20264e-15
    C18 (QN\#7 VSS!) capacitor c=12.1951a
    C19 (VSS!\#2 QN\#6) capacitor c=72.6356a
    C240 (QN\#6 CK\#5) capacitor c=68.4719a
    C20 (VSS!\#4 QN\#4) capacitor c=494.068a
    C134 (Q\#3 QN\#4) capacitor c=242.567a
    C237 (QN\#4 CK) capacitor c=585.92a
    C241 (CK\#2 QN\#4) capacitor c=9.04055e-18
    C243 (RNi\#2311 QN\#4) capacitor c=610.548a
    C260 (QN\#4 13) capacitor c=5.89427e-15
    C21 (VSS!\#4 QN\#3) capacitor c=618.325a
    C135 (Q\#3 QN\#3) capacitor c=108.661a
    C239 (QN\#3 CK\#5) capacitor c=560.201a
    C244 (QN\#3 RNi\#2311) capacitor c=10.2195a
    C251 (QN\#3 Y2\#2317) capacitor c=4.54541e-18
    C261 (QN\#3 13) capacitor c=5.5832e-15
    C26 (VDD!\#3 VSS!) capacitor c=108.756a
    C295 (VDD!\#3 Y4\#8) capacitor c=24.5998a
    C319 (VDD!\#3 13) capacitor c=135.848f
    C27 (CK\#8 VSS!) capacitor c=3.08637e-18
    C356 (Y4\#8 CK\#8) capacitor c=603.761a
    C378 (CK\#8 13) capacitor c=3.57615e-15
    C28 (CK\#1 VSS!) capacitor c=4.98943e-19
    C357 (Y4\#8 CK\#1) capacitor c=589.934a
    C358 (Y4\#2 CK\#1) capacitor c=24.8498a
    C379 (CK\#1 13) capacitor c=3.52929e-15
    C29 (VSS!\#2311 CK) capacitor c=94.7312a
    C30 (VSS!\#2312 CK) capacitor c=94.7312a
    C31 (VSS!\#2313 CK) capacitor c=95.7291a
    C14 (VSS!\#2313 SN\#8) capacitor c=179.76a
    C89 (VSS!\#6 net8\#2) capacitor c=105.554a
    C179 (SN\#8 CK) capacitor c=282.751a
    C218 (SN\#8 13) capacitor c=1.31003e-15
    C224 (net8\#2 SN\#8) capacitor c=83.616a
    C225 (SN\#6 net8\#2) capacitor c=1.83588e-18
    C387 (net8\#2 CK) capacitor c=60.7985a
    C586 (net8\#2 13) capacitor c=220.425a
    C88 (VSS!\#6 net8) capacitor c=73.7603a
    C386 (net8 CK) capacitor c=68.4719a
    C585 (net8 13) capacitor c=221.122a
    C36 (VSS!\#4 CK\#3) capacitor c=61.2785a
    C381 (CK\#3 13) capacitor c=776.506a
    C37 (net13\#5 VSS!) capacitor c=9.39651e-18
    C418 (net13\#5 13) capacitor c=1.28657e-15
    C39 (net13\#3 VSS!) capacitor c=138.401a
    C342 (net13\#3 CK) capacitor c=56.3348a
    C420 (net13\#3 13) capacitor c=1.08667e-15
    C43 (VSS!\#2312 RNi\#6) capacitor c=179.406a
    C94 (VSS!\#4 net10) capacitor c=103.983a
    C345 (RNi\#6 CK) capacitor c=566.617a
    C350 (CK\#2 RNi\#6) capacitor c=8.74272e-18
    C395 (net10 CK) capacitor c=67.4315a
    C466 (RNi\#6 13) capacitor c=1.98416e-15
    C472 (RNi\#6 net10) capacitor c=83.616a
    C591 (net10 13) capacitor c=221.122a
    C95 (VSS!\#4 net10\#2) capacitor c=73.7811a
    C396 (net10\#2 CK) capacitor c=63.0371a
    C397 (net10\#2 CK\#3) capacitor c=83.616a
    C398 (CK\#2 net10\#2) capacitor c=15.1599a
    C592 (net10\#2 13) capacitor c=221.343a
    C44 (RNi\#2318 VSS!) capacitor c=12.9931a
    C189 (RNi\#2318 SN\#1) capacitor c=246.055a
    C45 (RNi\#2317 VSS!) capacitor c=18.7788a
    C416 (RNi\#2317 net13\#5) capacitor c=244.284a
    C47 (RNi\#9 VSS!) capacitor c=6.83588e-18
    C434 (RNi\#9 Y4\#8) capacitor c=242.121a
    C453 (RNi\#9 Y2\#2317) capacitor c=598.126a
    C469 (RNi\#9 13) capacitor c=5.83607e-15
    C48 (RNi\#2313 VSS!) capacitor c=8.6169e-18
    C116 (RNi\#2313 D) capacitor c=10.0198a
    C118 (Y4\#2313 D) capacitor c=55.7344a
    C56 (Y4\#2313 VSS!) capacitor c=5.7836e-18
    C117 (RNi\#2313 D\#3) capacitor c=12.6982a
    C119 (Y4\#2313 D\#2) capacitor c=434.763a
    C120 (D\#3 Y4\#2313) capacitor c=276.353a
    C124 (D\#4 13) capacitor c=3.50057e-15
    C435 (RNi\#2313 Y4\#8) capacitor c=36.6002a
    C470 (RNi\#2313 13) capacitor c=6.2037e-15
    C478 (RNi\#2312 X53_5) capacitor c=487.384a
    C320 (VDD!\#1 X53_5) capacitor c=462.948a
    C521 (Y4\#2312 X53_5) capacitor c=406.381a
    C112 (VDD!\#22 D\#2) capacitor c=155.241a
    C291 (Y4\#2313 VDD!\#22) capacitor c=107.65a
    C321 (VDD!\#22 X52_5) capacitor c=328.32a
    C522 (Y4\#2313 X52_5) capacitor c=315.034a
    C128 (D\#2 X52_5) capacitor c=453.96a
    C121 (Y3\#2313 D\#2) capacitor c=36.2792a
    C78 (Y3\#2313 VSS!) capacitor c=4.49724e-18
    C568 (Y3\#2313 13) capacitor c=184.717a
    C3 (VSS!\#1 D\#4) capacitor c=66.411a
    C42 (VSS!\#1 RNi\#2314) capacitor c=184.219a
    C464 (RNi\#2314 13) capacitor c=2.08589e-15
    C49 (VSS!\#2 RNi\#2310) capacitor c=61.2785a
    C346 (CK\#5 RNi\#2310) capacitor c=595.066a
    C465 (RNi\#2310 13) capacitor c=1.97064e-15
    C149 (Q\#2310 RNi\#8) capacitor c=33.8606a
    C425 (Y4\#8 RNi\#8) capacitor c=349.436a
    C462 (RNi\#8 13) capacitor c=2.27235e-15
    C50 (VSS!\#6 RNi) capacitor c=169.124a
    C343 (RNi CK) capacitor c=1.09018e-15
    C51 (VSS!\#6 RNi\#2) capacitor c=73.7811a
    C188 (RNi\#2 SN\#4) capacitor c=80.8146a
    C349 (RNi\#2 CK) capacitor c=68.4915a
    C52 (Y4\#7 VSS!) capacitor c=4.07716e-18
    C355 (CK\#8 Y4\#7) capacitor c=34.5781a
    C513 (Y4\#7 13) capacitor c=1.12362e-15
    C53 (Y4\#3 VSS!) capacitor c=1.32962e-18
    C195 (SN\#7 Y4\#3) capacitor c=34.5781a
    C514 (Y4\#3 13) capacitor c=1.06092e-15
    C57 (Y4\#2315 VSS!) capacitor c=8.32077e-18
    C503 (Y4\#2315 Y3\#2313) capacitor c=148.356a
    C58 (Y4\#2311 VSS!\#1) capacitor c=163.905a
    C60 (VSS!\#2 Y4\#5) capacitor c=69.8273a
    C515 (Y4\#5 13) capacitor c=3.63097e-15
    C61 (VSS!\#6 Y4) capacitor c=61.3093a
    C198 (SN\#6 Y4) capacitor c=2.52051e-18
    C354 (Y4 CK) capacitor c=575.996a
    C512 (13 Y4) capacitor c=3.17114e-15
    C517 (net8 Y4) capacitor c=83.616a
    C62 (Y1\#9 VSS!) capacitor c=7.40801e-18
    C360 (Y1\#9 CK\#1) capacitor c=33.8606a
    C533 (Y1\#9 13) capacitor c=177.251a
    C63 (Y1\#8 VSS!) capacitor c=34.1498a
    C203 (Y1\#8 SN\#7) capacitor c=639.704a
    C439 (RNi\#2318 Y1\#8) capacitor c=24.6736a
    C64 (VSS!\#4 Y1\#2311) capacitor c=59.6561a
    C205 (SN\#6 Y1\#2311) capacitor c=2.58005e-18
    C361 (Y1\#2311 CK) capacitor c=567.131a
    C364 (CK\#2 Y1\#2311) capacitor c=8.75064e-18
    C437 (RNi\#3 Y1\#2311) capacitor c=604.668a
    C440 (RNi\#5 Y1\#2311) capacitor c=5.12337e-18
    C534 (Y1\#2311 13) capacitor c=4.14436e-15
    C65 (VSS!\#6 Y1) capacitor c=91.675a
    C204 (SN\#6 Y1) capacitor c=4.59625e-18
    C359 (Y1 CK) capacitor c=1.06846e-15
    C363 (CK\#2 Y1) capacitor c=17.4697a
    C436 (RNi\#3 Y1) capacitor c=519.815a
    C66 (VSS!\#6 Y1\#2) capacitor c=64.4553a
    C362 (Y1\#2 CK) capacitor c=63.7563a
    C67 (Y2\#20 VSS!) capacitor c=3.8424e-18
    C365 (Y2\#20 CK\#8) capacitor c=34.5781a
    C547 (Y2\#20 13) capacitor c=1.68071e-15
    C68 (Y2\#2315 VSS!) capacitor c=7.26522e-18
    C548 (Y2\#2315 13) capacitor c=1.91796e-15
    C69 (Y2\#4 VSS!) capacitor c=8.35411e-18
    C491 (Y4\#3 Y2\#4) capacitor c=34.5781a
    C492 (Y4\#8 Y2\#4) capacitor c=589.524a
    C496 (Y4\#2 Y2\#4) capacitor c=24.8325a
    C549 (Y2\#4 13) capacitor c=4.44052e-15
    C71 (Y2\#6 VSS!) capacitor c=1.60958e-18
    C494 (Y2\#6 Y4\#8) capacitor c=94.915a
    C497 (Y4\#2 Y2\#6) capacitor c=3.99811e-18
    C554 (Y2\#6 13) capacitor c=2.99881e-15
    C73 (VSS!\#2311 Y2\#2313) capacitor c=179.398a
    C97 (VSS!\#4 net3\#2) capacitor c=104.004a
    C208 (SN\#9 Y2\#2313) capacitor c=288.854a
    C366 (Y2\#2313 CK) capacitor c=567.425a
    C372 (CK\#2 Y2\#2313) capacitor c=8.75519e-18
    C400 (net3\#2 CK) capacitor c=67.4508a
    C401 (CK\#2 net3\#2) capacitor c=1.96429e-18
    C551 (Y2\#2313 13) capacitor c=2.54149e-15
    C559 (net3\#2 Y2\#2313) capacitor c=83.616a
    C160 (Y2\#2314 Q) capacitor c=75.9005a
    C162 (Q\#2311 Y2\#2314) capacitor c=42.5849a
    C213 (Y2\#2314 SN\#9) capacitor c=63.8795a
    C252 (Y2\#2314 QN\#5) capacitor c=42.6504a
    C253 (Y2\#2314 QN\#3) capacitor c=3.5634e-19
    C451 (Y2\#2314 RNi\#3) capacitor c=89.019a
    C452 (Y2\#2314 RNi\#5) capacitor c=8.73366e-19
    C498 (Y2\#2314 Y4\#8) capacitor c=74.0073a
    C499 (Y2\#2314 Y4\#2) capacitor c=3.11741e-18
    C594 (net3\#2 13) capacitor c=221.343a
    C96 (VSS!\#4 net3) capacitor c=73.7603a
    C226 (SN\#2310 net3) capacitor c=83.616a
    C227 (SN\#9 net3) capacitor c=1.83588e-18
    C399 (net3 CK) capacitor c=59.8553a
    C593 (net3 13) capacitor c=220.204a
    C255 (QN\#2311 Y2\#2314) capacitor c=75.5441a
    C248 (QN\#2311 Y4\#8) capacitor c=1.23924e-15
    C254 (QN\#2311 Y2\#2317) capacitor c=483.91a
    C74 (VSS!\#4 Y2\#5) capacitor c=73.7603a
    C371 (Y2\#5 CK) capacitor c=67.4315a
    C375 (CK\#2 Y2\#5) capacitor c=1.04045e-18
    C529 (Y2\#5 Y1\#2311) capacitor c=80.8146a
    C75 (VSS!\#6 Y2\#3) capacitor c=489.667a
    C211 (SN\#6 Y2\#3) capacitor c=2.58204e-18
    C367 (Y2\#3 CK) capacitor c=562.488a
    C373 (CK\#2 Y2\#3) capacitor c=8.679e-18
    C445 (RNi\#3 Y2\#3) capacitor c=610.552a
    C531 (Y1\#2 Y2\#3) capacitor c=139.082a
    C552 (Y2\#3 13) capacitor c=5.78719e-15
    C76 (VSS!\#6 Y2\#2) capacitor c=614.384a
    C212 (SN\#6 Y2\#2) capacitor c=4.59649e-18
    C187 (RNi\#3 SN) capacitor c=3.79181e-15
    C194 (Y4 SN) capacitor c=570.21a
    C201 (Y1 SN) capacitor c=1.0398e-15
    C202 (Y1\#2311 SN) capacitor c=583.681a
    C207 (Y2\#3 SN) capacitor c=584.131a
    C210 (Y2\#2 SN) capacitor c=1.03986e-15
    C369 (Y2\#2 CK) capacitor c=1.06264e-15
    C374 (CK\#2 Y2\#2) capacitor c=16.3962a
    C447 (RNi\#3 Y2\#2) capacitor c=517.839a
    C450 (RNi\#5 Y2\#2) capacitor c=4.38766e-18
    C526 (Y2\#2 Y1) capacitor c=105.372a
    C438 (RNi\#3 Y1\#3) capacitor c=554.355a
    C441 (RNi\#5 Y1\#3) capacitor c=4.51285e-18
    C344 (CK\#1 RNi\#4) capacitor c=34.5781a
    C426 (Y4\#8 RNi\#4) capacitor c=335.406a
    C430 (Y4\#2 RNi\#4) capacitor c=14.1283a
    C443 (Y2\#6 RNi\#4) capacitor c=15.3669a
    C463 (RNi\#4 13) capacitor c=2.30249e-15
    C484 (Y1\#3 Y4\#8) capacitor c=1.12322e-15
    C488 (Y4\#2 Y1\#3) capacitor c=66.5048a
    C535 (Y1\#3 13) capacitor c=19.1731f
    C555 (Y2\#2 13) capacitor c=9.88464e-15
    C174 (SN\#2312 QN\#5) capacitor c=34.5781a
    C196 (Y4\#8 SN\#2312) capacitor c=566.375a
    C199 (Y4\#2 SN\#2312) capacitor c=23.8574a
    C206 (Y2\#2315 SN\#2312) capacitor c=36.2794a
    C214 (SN\#2312 13) capacitor c=2.85775e-15
    C77 (Y3 VSS!) capacitor c=2.3736e-18
    C256 (QN\#7 Y3) capacitor c=28.8734a
    C500 (Y4\#8 Y3) capacitor c=98.7308a
    C544 (Y2\#20 Y3) capacitor c=15.515a
    C567 (13 Y3) capacitor c=2.98824e-15
    C79 (Y3\#6 VSS!) capacitor c=17.9549a
    C457 (RNi\#2311 Y3\#6) capacitor c=544.806a
    C502 (Y4\#8 Y3\#6) capacitor c=1.37785e-15
    C572 (Y3\#6 13) capacitor c=19.6975f
    C80 (VSS!\#1 Y3\#2315) capacitor c=65.6319a
    C455 (RNi\#2311 Y3\#2315) capacitor c=603.402a
    C459 (RNi\#2313 Y3\#2315) capacitor c=13.4146a
    C460 (RNi\#2313 Y3\#5) capacitor c=24.2368a
    C84 (VSS!\#2 Y3\#5) capacitor c=181.602a
    C458 (Y3\#5 RNi\#2311) capacitor c=545.39a
    C504 (Y4\#2311 Y3\#2315) capacitor c=95.5625a
    C507 (Y3\#5 Y4\#5) capacitor c=95.5608a
    C508 (Y3\#5 Y4\#2311) capacitor c=139.797a
    C570 (Y3\#2315 13) capacitor c=4.5824e-15
    C81 (Y3\#2311 VSS!) capacitor c=1.42055e-18
    C510 (Y3\#2311 Y4\#8) capacitor c=134.092a
    C546 (Y3\#2311 Y2\#20) capacitor c=637.65a
    C83 (Y3\#2314 VSS!) capacitor c=6.14541e-18
    C316 (VDD!\#3 Y3\#2314) capacitor c=18.2136a
    C511 (Y3\#2314 Y4\#2315) capacitor c=703.543a
    C573 (Y3\#2314 13) capacitor c=5.87633e-15
    C578 (Y3\#2314 X51_5) capacitor c=96.1789a
    C523 (Y4\#2315 X51_5) capacitor c=348.52a
    C577 (Y3\#2313 X51_5) capacitor c=356.549a
    C322 (VDD!\#23 X51_5) capacitor c=333.968a
    C292 (Y4\#2315 VDD!\#23) capacitor c=115.933a
    C311 (VDD!\#23 Y3\#2313) capacitor c=144.16a
    C86 (net14 VSS!) capacitor c=72.6356a
    C223 (SN\#4 net14) capacitor c=83.616a
    C384 (net14 CK) capacitor c=68.4719a
    C471 (RNi\#2 net14) capacitor c=41.361a
    C190 (SN\#2 RNi\#3) capacitor c=8.00856e-19
    C444 (RNi\#3 Y2) capacitor c=552.238a
    C221 (SN\#2 13) capacitor c=5.93481e-18
    C495 (Y4\#2 Y2) capacitor c=94.8866a
    C527 (Y1\#3 Y2) capacitor c=140.807a
    C583 (net14 13) capacitor c=221.122a
    C87 (net14\#2 VSS!) capacitor c=105.129a
    C385 (net14\#2 CK) capacitor c=68.4915a
    C584 (net14\#2 13) capacitor c=221.343a
    C186 (net13 SN) capacitor c=34.8887a
    C228 (net4\#2 SN\#2310) capacitor c=83.616a
    C611 (net4\#2 net3) capacitor c=39.8112a
    C392 (CK\#3 net9) capacitor c=83.616a
    C610 (net10\#2 net9) capacitor c=39.8112a
    C154 (Y4\#2 Q\#7) capacitor c=10.3532a
    C490 (Y1\#2310 Y4\#2) capacitor c=24.7525a
    C159 (Q\#9 Y2\#6) capacitor c=28.8734a
    C309 (VDD!\#2313 Y2\#6) capacitor c=29.9985a
    C130 (QN Q) capacitor c=80.0008a
    C262 (QN\#4 net4) capacitor c=83.616a
    C264 (QN\#6 net5\#2) capacitor c=39.8112a
    C263 (net5\#2 QN\#3) capacitor c=1.83462e-18
    C422 (net14\#2 net13\#7) capacitor c=83.616a
    C302 (VDD!\#2316 Y1\#3) capacitor c=41.1742a
    C575 (Y3\#5 net12) capacitor c=41.34a
    C475 (RNi\#2314 net2) capacitor c=83.616a
    C293 (VDD!\#24 Y4\#7) capacitor c=158.19a
    C312 (Y3\#7 VDD!\#24) capacitor c=111.119a
    C505 (Y3\#7 Y4\#7) capacitor c=438.63a
    C165 (Q\#4 13) capacitor c=20.0429f
    C137 (QN\#2311 Q\#4) capacitor c=117.734a
    C142 (VDD!\#9 Q\#4) capacitor c=10.9119a
    C236 (VDD!\#9 QN\#2311) capacitor c=30.4203a
    C143 (VDD!\#9 Q\#2311) capacitor c=28.7505a
    C136 (Q\#2311 QN\#2310) capacitor c=609.217a
    C170 (Q\#2311 X45_5) capacitor c=112.751a
    C267 (QN\#2310 X45_5) capacitor c=316.116a
    C132 (QN\#2310 Q\#2310) capacitor c=147.723a
    C169 (Q\#2310 X45_5) capacitor c=356.549a
    C328 (VDD!\#29 X45_5) capacitor c=333.968a
    C138 (VDD!\#29 Q\#2310) capacitor c=144.16a
    C234 (QN\#2310 VDD!\#29) capacitor c=111.825a
    C247 (QN\#2310 Y4\#8) capacitor c=289.068a
    C152 (Q\#4 Y4\#8) capacitor c=1.2172e-15
    C506 (Y3\#7 Y4\#8) capacitor c=413.366a
    C144 (VDD!\#2310 Q\#4) capacitor c=41.1742a
    C153 (Q\#7 Y4\#8) capacitor c=327.485a
    C129 (Q\#7 SN\#2312) capacitor c=644.683a
    C140 (Q\#7 VDD!\#31) capacitor c=107.267a
    C175 (VDD!\#31 SN\#2312) capacitor c=158.19a
    C229 (SN\#2312 X43_5) capacitor c=453.221a
    C172 (Q\#7 X43_5) capacitor c=316.082a
    C330 (VDD!\#31 X43_5) capacitor c=328.08a
    C139 (Q\#5 VDD!\#30) capacitor c=110.665a
    C133 (Q\#5 QN\#5) capacitor c=672.681a
    C235 (VDD!\#30 QN\#5) capacitor c=158.19a
    C268 (QN\#5 X44_5) capacitor c=453.221a
    C329 (VDD!\#30 X44_5) capacitor c=333.968a
    C171 (Q\#5 X44_5) capacitor c=316.042a
    C489 (Y1\#2310 Y4\#8) capacitor c=587.624a
    C536 (Y1\#2310 13) capacitor c=5.9638e-15
    C141 (Q\#9 VDD!\#32) capacitor c=86.3337a
    C157 (Q\#4 Y2\#2317) capacitor c=483.91a
    C158 (Q\#9 Y2\#2315) capacitor c=613.811a
    C304 (VDD!\#32 Y2\#2315) capacitor c=160.516a
    C331 (VDD!\#32 X42_5) capacitor c=333.024a
    C562 (Y2\#2315 X42_5) capacitor c=461.773a
    C173 (Q\#9 X42_5) capacitor c=156.865a
    C249 (Y2\#2317 QN) capacitor c=479.717a
    C258 (13 QN) capacitor c=14.3931f
    C131 (Q\#2312 QN) capacitor c=185.105a
    C167 (Q\#3 net4) capacitor c=41.34a
    C595 (net4 13) capacitor c=221.122a
    C98 (VSS!\#4 net4) capacitor c=72.6356a
    C92 (VSS!\#4 net9) capacitor c=73.7603a
    C589 (net9 13) capacitor c=221.122a
    C93 (VSS!\#4 net9\#2) capacitor c=72.6564a
    C590 (net9\#2 13) capacitor c=221.343a
    C99 (VSS!\#4 net4\#2) capacitor c=73.7811a
    C596 (net4\#2 13) capacitor c=221.343a
    C402 (net4 CK) capacitor c=67.4315a
    C391 (net9 CK) capacitor c=67.4315a
    C393 (net9\#2 CK) capacitor c=67.4508a
    C403 (net4\#2 CK) capacitor c=67.4508a
    C82 (VSS!\#2310 Y3\#3) capacitor c=179.995a
    C571 (Y3\#3 13) capacitor c=4.43765e-15
    C168 (net5\#2 Q\#2312) capacitor c=83.616a
    C598 (net5\#2 13) capacitor c=221.343a
    C101 (VSS!\#2 net5\#2) capacitor c=72.6564a
    C102 (VSS!\#2 net6) capacitor c=103.983a
    C574 (Y3\#3 net6) capacitor c=83.616a
    C599 (net6 13) capacitor c=221.122a
    C100 (VSS!\#2 net5) capacitor c=73.7603a
    C597 (net5 13) capacitor c=221.122a
    C103 (VSS!\#2 net6\#2) capacitor c=73.7811a
    C600 (net6\#2 13) capacitor c=221.343a
    C612 (net6\#2 net5) capacitor c=39.8112a
    C407 (CK\#5 net6) capacitor c=68.4719a
    C238 (CK\#5 QN) capacitor c=617.785a
    C376 (CK\#5 Y3\#3) capacitor c=597.152a
    C405 (CK\#5 net5) capacitor c=68.4719a
    C406 (net5\#2 CK\#5) capacitor c=68.4915a
    C242 (RNi\#2311 QN) capacitor c=1.13549e-15
    C408 (net6\#2 CK\#5) capacitor c=68.4915a
    C456 (RNi\#2311 Y3\#3) capacitor c=590.257a
    C501 (Y4\#8 Y3\#2) capacitor c=593.725a
    C545 (Y2\#2317 Y3\#2) capacitor c=586.895a
    C569 (Y3\#2 13) capacitor c=4.37242e-15
    C104 (VSS!\#2 net11) capacitor c=73.7603a
    C410 (CK\#5 net11) capacitor c=67.9406a
    C601 (net11 13) capacitor c=221.122a
    C105 (VSS!\#2 net11\#2) capacitor c=104.004a
    C411 (net11\#2 CK\#5) capacitor c=68.4915a
    C602 (net11\#2 13) capacitor c=221.343a
    C106 (VSS!\#2 net12) capacitor c=76.0632a
    C603 (net12 13) capacitor c=237.088a
    C107 (VSS!\#2 net12\#2) capacitor c=77.2097a
    C604 (net12\#2 13) capacitor c=237.325a
    C613 (net12\#2 net11) capacitor c=39.8112a
    C72 (VSS!\#9 Y2\#2318) capacitor c=179.398a
    C560 (net11\#2 Y2\#2318) capacitor c=83.616a
    C368 (CK\#5 Y2\#2318) capacitor c=600.698a
    C550 (Y2\#2318 13) capacitor c=2.61707e-15
    C404 (CK\#2 net4\#2) capacitor c=2.08119e-18
    C394 (CK\#2 net9\#2) capacitor c=2.08119e-18
    C390 (CK\#2 net7) capacitor c=1.78339e-18
    C388 (net7 CK) capacitor c=67.4315a
    C587 (net7 13) capacitor c=221.122a
    C90 (VSS!\#6 net7) capacitor c=72.6356a
    C91 (VSS!\#6 net7\#2) capacitor c=73.7811a
    C389 (net7\#2 CK) capacitor c=67.729a
    C341 (net13\#7 CK) capacitor c=596.878a
    C38 (VSS!\#2314 net13\#7) capacitor c=179.999a
    C419 (net13\#7 13) capacitor c=2.00319e-15
    C588 (net7\#2 13) capacitor c=221.343a
    C233 (QN\#8 VDD!\#28) capacitor c=107.267a
    C245 (QN\#8 RNi\#8) capacitor c=665.355a
    C285 (VDD!\#28 RNi\#8) capacitor c=155.241a
    C454 (RNi\#8 Y3\#2) capacitor c=35.7731a
    C327 (VDD!\#28 X46_5) capacitor c=328.08a
    C479 (RNi\#8 X46_5) capacitor c=453.221a
    C266 (QN\#8 X46_5) capacitor c=316.082a
    C257 (QN\#7 Y3\#2) capacitor c=636.955a
    C232 (QN\#7 VDD!\#27) capacitor c=86.3337a
    C315 (VDD!\#27 Y3\#2) capacitor c=157.571a
    C265 (QN\#7 X47_5) capacitor c=157.049a
    C326 (VDD!\#27 X47_5) capacitor c=333.024a
    C582 (Y3\#2 X47_5) capacitor c=461.773a
    C318 (VDD!\#6 Y3) capacitor c=29.9984a
    C275 (13 RN) capacitor c=5.63819e-15
    C23 (VSS!\#8 RN) capacitor c=25.3a
    C24 (VSS!\#8 RN\#4) capacitor c=176.517a
    C277 (RN\#4 13) capacitor c=1.46203e-15
    C25 (RN\#3 VSS!\#8) capacitor c=1.28111e-18
    C278 (RN\#3 13) capacitor c=312.694a
    C270 (net13\#3 RN) capacitor c=64.9871a
    C272 (net13\#4 RN) capacitor c=376.425a
    C271 (net13\#3 RN\#4) capacitor c=170.87a
    C274 (RN\#3 net13\#4) capacitor c=24.5239a
    C273 (net13\#4 RN\#2) capacitor c=326.828a
    C421 (net13\#4 13) capacitor c=3.0588e-15
    C417 (13 net13) capacitor c=5.32012e-15
    C415 (RNi\#2317 net13) capacitor c=749.436a
    C269 (VDD!\#21 RN\#2) capacitor c=182.997a
    C283 (net13\#4 VDD!\#21) capacitor c=100.498a
    C279 (RN\#2 X33_5) capacitor c=509.926a
    C424 (net13\#4 X33_5) capacitor c=175.343a
    C340 (VDD!\#21 X33_5) capacitor c=485.485a
    C289 (VDD!\#20 RNi\#2317) capacitor c=10.3692a
    C282 (VDD!\#40 net13\#5) capacitor c=183.127a
    C288 (VDD!\#40 RNi\#2317) capacitor c=112.844a
    C339 (VDD!\#40 X34_5) capacitor c=182.825a
    C423 (net13\#5 X34_5) capacitor c=511.921a
    C483 (RNi\#2317 X34_5) capacitor c=182.825a
    C301 (VDD!\#2315 Y1\#2310) capacitor c=28.7505a
    C300 (VDD!\#2315 Y1\#3) capacitor c=10.9119a
    C303 (VDD!\#26 Y2\#20) capacitor c=158.19a
    C310 (VDD!\#2315 Y2) capacitor c=30.4203a
    C314 (Y3\#2311 VDD!\#26) capacitor c=106.406a
    C325 (VDD!\#26 X48_5) capacitor c=333.024a
    C561 (Y2\#20 X48_5) capacitor c=453.221a
    C581 (Y3\#2311 X48_5) capacitor c=315.899a
    C323 (VDD!\#24 X50_5) capacitor c=333.968a
    C524 (Y4\#7 X50_5) capacitor c=453.051a
    C579 (Y3\#7 X50_5) capacitor c=297.685a
    C509 (Y3\#9 Y4\#8) capacitor c=140.533a
    C313 (Y3\#9 VDD!\#25) capacitor c=107.267a
    C519 (Y4\#5 net12) capacitor c=83.616a
    C280 (VDD!\#25 CK\#8) capacitor c=158.19a
    C377 (Y3\#9 CK\#8) capacitor c=644.676a
    C409 (CK\#6 net11) capacitor c=83.616a
    C412 (net12\#2 CK\#6) capacitor c=83.616a
    C324 (VDD!\#25 X49_5) capacitor c=328.08a
    C413 (CK\#8 X49_5) capacitor c=453.221a
    C580 (Y3\#9 X49_5) capacitor c=316.082a
    C473 (RNi\#2310 net5) capacitor c=83.616a
    C474 (net6\#2 RNi\#2310) capacitor c=83.616a
    C476 (RNi\#2311 net2) capacitor c=3.42762e-18
    C477 (net2\#2 RNi\#2311) capacitor c=3.42859e-18
    C607 (net2 13) capacitor c=237.088a
    C608 (net2\#2 13) capacitor c=237.325a
    C110 (VSS!\#1 net2) capacitor c=103.983a
    C111 (net2\#2 VSS!\#1) capacitor c=73.7811a
    C108 (VSS!\#1 net1) capacitor c=77.1879a
    C605 (net1 13) capacitor c=237.088a
    C606 (net1\#2 13) capacitor c=237.325a
    C109 (net1\#2 VSS!\#1) capacitor c=76.085a
    C614 (net2\#2 net1) capacitor c=39.8112a
    C126 (D\#4 net1) capacitor c=83.616a
    C127 (net2\#2 D\#4) capacitor c=83.616a
    C485 (Y1\#4 Y4\#8) capacitor c=156.822a
    C487 (Y1\#6 Y4\#8) capacitor c=298.786a
    C518 (net7\#2 Y4) capacitor c=83.616a
    C609 (net7\#2 net8) capacitor c=39.8112a
    C520 (Y4\#2311 net1\#2) capacitor c=41.34a
    C576 (net1\#2 Y3\#2315) capacitor c=83.616a
    C537 (Y1\#2 net7) capacitor c=41.34a
    C556 (Y2\#3 net7) capacitor c=83.616a
    C557 (net9\#2 Y2\#2) capacitor c=1.83462e-18
    C558 (Y2\#5 net9\#2) capacitor c=39.8112a
    C286 (VDD!\#33 RNi\#4) capacitor c=155.241a
    C305 (Y2\#7 VDD!\#33) capacitor c=106.406a
    C448 (Y2\#7 RNi\#4) capacitor c=660.925a
    C480 (RNi\#4 X41_5) capacitor c=453.221a
    C332 (VDD!\#33 X41_5) capacitor c=333.024a
    C563 (Y2\#7 X41_5) capacitor c=316.082a
    C281 (VDD!\#34 CK\#1) capacitor c=155.241a
    C306 (Y2\#9 VDD!\#34) capacitor c=107.267a
    C370 (Y2\#9 CK\#1) capacitor c=665.355a
    C414 (CK\#1 X40_5) capacitor c=453.221a
    C333 (VDD!\#34 X40_5) capacitor c=328.08a
    C564 (Y2\#9 X40_5) capacitor c=316.082a
    C296 (VDD!\#35 Y1\#9) capacitor c=144.16a
    C307 (Y2\#2311 VDD!\#35) capacitor c=111.825a
    C528 (Y2\#2311 Y1\#9) capacitor c=147.723a
    C334 (VDD!\#35 X39_5) capacitor c=333.968a
    C539 (Y1\#9 X39_5) capacitor c=356.549a
    C532 (Y1\#2310 Y2\#2311) capacitor c=615.939a
    C565 (Y2\#2311 X39_5) capacitor c=316.116a
    C540 (Y1\#2310 X39_5) capacitor c=112.751a
    C538 (net9\#2 Y1\#2311) capacitor c=83.616a
    C176 (VDD!\#38 SN\#7) capacitor c=158.794a
    C230 (SN\#7 X36_5) capacitor c=486.352a
    C299 (Y1\#8 VDD!\#38) capacitor c=86.3337a
    C337 (VDD!\#38 X36_5) capacitor c=331.309a
    C543 (Y1\#8 X36_5) capacitor c=172.116a
    C481 (RNi\#2318 X36_5) capacitor c=44.388a
    C287 (RNi\#2318 VDD!\#39) capacitor c=123.912a
    C177 (VDD!\#39 SN\#1) capacitor c=183.136a
    C231 (SN\#1 X35_5) capacitor c=512.696a
    C482 (RNi\#2318 X35_5) capacitor c=183.468a
    C338 (VDD!\#39 X35_5) capacitor c=160.254a
    C294 (VDD!\#37 Y4\#3) capacitor c=158.19a
    C297 (Y1\#4 VDD!\#36) capacitor c=111.119a
    C298 (Y1\#6 VDD!\#37) capacitor c=107.649a
    C486 (Y1\#6 Y4\#3) capacitor c=421.39a
    C336 (VDD!\#37 X37_5) capacitor c=356.74a
    C525 (Y4\#3 X37_5) capacitor c=453.048a
    C542 (Y1\#6 X37_5) capacitor c=315.034a
    C308 (VDD!\#36 Y2\#4) capacitor c=158.19a
    C530 (Y1\#4 Y2\#4) capacitor c=672.671a
    C335 (VDD!\#36 X38_5) capacitor c=333.968a
    C541 (Y1\#4 X38_5) capacitor c=316.082a
    C566 (Y2\#4 X38_5) capacitor c=453.202a
    MX53_M0_unmatched (Y4\#2312 RNi\#2312 VDD!\#1 VDD!\#1) pch w=4e-06 \
        l=1e-06 as=0 ad=1e-11 ps=0 pd=1.3e-05 sa=2e-06 sb=2e-06
    MX52_M0_unmatched (Y4\#2313 D\#2 VDD!\#22 VDD!\#22) pch w=4e-06 \
        l=1e-06 as=0 ad=1e-11 ps=0 pd=1.3e-05 sa=2e-06 sb=2e-06
    MX51_M0_unmatched (Y4\#2315 Y3\#2313 VDD!\#23 VDD!\#23) pch w=4e-06 \
        l=1e-06 as=0 ad=1e-11 ps=0 pd=1.3e-05 sa=2e-06 sb=2e-06
    MX50_M0_unmatched (Y3\#7 Y4\#7 VDD!\#24 VDD!\#24) pch w=4e-06 l=1e-06 \
        as=0 ad=1e-11 ps=0 pd=1.3e-05 sa=2e-06 sb=2e-06
    MX45_M0_unmatched (QN\#2310 Q\#2310 VDD!\#29 VDD!\#29) pch w=4e-06 \
        l=1e-06 as=0 ad=1e-11 ps=0 pd=1.3e-05 sa=2e-06 sb=2e-06
    MX43_M0_unmatched (Q\#7 SN\#2312 VDD!\#31 VDD!\#31) pch w=4e-06 \
        l=1e-06 as=0 ad=1e-11 ps=0 pd=1.3e-05 sa=2e-06 sb=2e-06
    MX44_M0_unmatched (Q\#5 QN\#5 VDD!\#30 VDD!\#30) pch w=4e-06 l=1e-06 \
        as=0 ad=1e-11 ps=0 pd=1.3e-05 sa=2e-06 sb=2e-06
    MX42_M0_unmatched (Q\#9 Y2\#2315 VDD!\#32 VDD!\#32) pch w=4e-06 \
        l=1e-06 as=0 ad=1e-11 ps=0 pd=1.3e-05 sa=2e-06 sb=2e-06
    MX46_M0_unmatched (QN\#8 RNi\#8 VDD!\#28 VDD!\#28) pch w=4e-06 l=1e-06 \
        as=0 ad=1e-11 ps=0 pd=1.3e-05 sa=2e-06 sb=2e-06
    MX47_M0_unmatched (QN\#7 Y3\#2 VDD!\#27 VDD!\#27) pch w=4e-06 l=1e-06 \
        as=0 ad=1e-11 ps=0 pd=1.3e-05 sa=2e-06 sb=2e-06
    MX33_M0_unmatched (net13\#4 RN\#2 VDD!\#21 VDD!\#21) pch w=4e-06 \
        l=1e-06 as=0 ad=1e-11 ps=0 pd=1.3e-05 sa=2e-06 sb=2e-06
    MX34_M0_unmatched (RNi\#2317 net13\#5 VDD!\#40 VDD!\#40) pch w=4e-06 \
        l=1e-06 as=0 ad=1e-11 ps=0 pd=1.3e-05 sa=2e-06 sb=2e-06
    MX48_M0_unmatched (Y3\#2311 Y2\#20 VDD!\#26 VDD!\#26) pch w=4e-06 \
        l=1e-06 as=0 ad=1e-11 ps=0 pd=1.3e-05 sa=2e-06 sb=2e-06
    MX49_M0_unmatched (Y3\#9 CK\#8 VDD!\#25 VDD!\#25) pch w=4e-06 l=1e-06 \
        as=0 ad=1e-11 ps=0 pd=1.3e-05 sa=2e-06 sb=2e-06
    MX41_M0_unmatched (Y2\#7 RNi\#4 VDD!\#33 VDD!\#33) pch w=4e-06 l=1e-06 \
        as=0 ad=1e-11 ps=0 pd=1.3e-05 sa=2e-06 sb=2e-06
    MX40_M0_unmatched (Y2\#9 CK\#1 VDD!\#34 VDD!\#34) pch w=4e-06 l=1e-06 \
        as=0 ad=1e-11 ps=0 pd=1.3e-05 sa=2e-06 sb=2e-06
    MX39_M0_unmatched (Y2\#2311 Y1\#9 VDD!\#35 VDD!\#35) pch w=4e-06 \
        l=1e-06 as=0 ad=1e-11 ps=0 pd=1.3e-05 sa=2e-06 sb=2e-06
    MX36_M0_unmatched (Y1\#8 SN\#7 VDD!\#38 VDD!\#38) pch w=4e-06 l=1e-06 \
        as=0 ad=1e-11 ps=0 pd=1.3e-05 sa=2e-06 sb=2e-06
    MX35_M0_unmatched (RNi\#2318 SN\#1 VDD!\#39 VDD!\#39) pch w=4e-06 \
        l=1e-06 as=0 ad=1e-11 ps=0 pd=1.3e-05 sa=2e-06 sb=2e-06
    MX37_M0_unmatched (Y1\#6 Y4\#3 VDD!\#37 VDD!\#37) pch w=4e-06 l=1e-06 \
        as=0 ad=1e-11 ps=0 pd=1.3e-05 sa=2e-06 sb=2e-06
    MX38_M0_unmatched (Y1\#4 Y2\#4 VDD!\#36 VDD!\#36) pch w=4e-06 l=1e-06 \
        as=0 ad=1e-11 ps=0 pd=1.3e-05 sa=2e-06 sb=2e-06
    Rc79 (VDD!\#3 VDD!\#4) resistor r=189.6m
    Rd35 (RNi\#5 RNi\#2311) resistor r=178.5325
    Rd45 (Y4\#2 Y4\#8) resistor r=89.064
    Rd21 (VSS!\#4 VSS!\#6) resistor r=576.6m
    Rc114 (RNi\#3 RNi\#5) resistor r=166.6304
    Rc115 (RNi\#3 RNi\#2311) resistor r=2.9246
    Rc65 (VSS!\#2 VSS!\#4) resistor r=576.6m
    Rc66 (VSS! VSS!\#6) resistor r=200.1m
    Rc9 (CK\#2 CK\#5) resistor r=493.5764
    Rc10 (CK\#5 CK) resistor r=9.2404
    Rc13 (CK\#2 CK) resistor r=105.2963
    Rs1 (13 VSS!) resistor r=50
    Rc77 (D\#2 D\#3) resistor r=1044.8411
    Rc99 (D\#3 D) resistor r=85.564
    Rd67 (Q\#2311 Q\#2310) resistor r=201.111
    Rc126 (Q\#2311 Q\#2312) resistor r=3744.2583
    Rc127 (Q Q\#3) resistor r=553.5043
    Rd1 (SN\#6 SN\#7) resistor r=2844.8411
    Rc124 (SN\#6 SN\#9) resistor r=1545.1519
    Rc51 (QN\#4 QN\#5) resistor r=3908.8093
    Rc52 (QN\#4 QN\#3) resistor r=1723.2665
    Rc57 (QN\#3 QN\#6) resistor r=10.1
    Rc100 (VDD!\#1 VDD!\#3) resistor r=2.7467
    Rc41 (CK\#1 CK\#2) resistor r=3444.8411
    Rc6 (VSS!\#4 VSS!\#2311) resistor r=5.0974
    Rd23 (VSS!\#4 VSS!\#2312) resistor r=6.7931
    Rc68 (VSS!\#2312 VSS!\#6) resistor r=22.1536
    Rd24 (VSS!\#6 VSS!\#2313) resistor r=5.0974
    Rc123 (SN\#6 SN\#8) resistor r=1036.0317
    Rc7 (net8 net8\#2) resistor r=10.1
    Rc44 (CK\#2 CK\#3) resistor r=436.0318
    Rc93 (RNi\#5 RNi\#6) resistor r=1636.0317
    Rc17 (net10 net10\#2) resistor r=10.1
    Rc15 (RNi\#3 RNi\#2318) resistor r=2.9889
    Rd43 (RNi\#3 RNi\#2317) resistor r=3.3227
    Rc18 (RNi\#2318 RNi\#2317) resistor r=50.1091
    Rd11 (RNi\#9 RNi\#2311) resistor r=85.464
    Rd30 (D\#3 D\#4) resistor r=2836.0317
    Rd34 (RNi\#2313 RNi\#2312) resistor r=2244.8411
    Rc78 (VDD!\#1 VDD!\#22) resistor r=108.4015
    Rd52 (VDD!\#22 VDD!\#3) resistor r=2.6763
    Rc94 (RNi\#2311 RNi\#2313) resistor r=87.364
    Rc21 (Y4\#2312 Y4\#2313) resistor r=38.95
    Rc24 (Y4\#2312 Y4\#2316) resistor r=3.116
    Rd40 (Y4\#2313 Y4\#2316) resistor r=2.8852
    Rd37 (Y4\#8 Y4\#2316) resistor r=615.5m
    Rd38 (VSS!\#1 VSS!\#2) resistor r=5.5378
    Rc46 (RNi\#2313 RNi\#2314) resistor r=1636.0317
    Rc95 (RNi\#9 RNi\#2310) resistor r=1636.0317
    Rd13 (RNi\#8 RNi\#9) resistor r=2244.8411
    Rd8 (RNi\#3 RNi) resistor r=840.853
    Rd36 (RNi RNi\#2) resistor r=10.1
    Rd44 (Y4\#2 Y4\#3) resistor r=1044.8411
    Rd39 (Y4\#2316 Y4\#2315) resistor r=2.5
    Rc20 (Y4\#2311 Y4\#2316) resistor r=2976.8799
    Rd42 (Y4\#8 Y4\#2311) resistor r=2831.2012
    Rc22 (Y4\#2 Y4) resistor r=2836.0317
    Rc35 (Y1 Y1\#2) resistor r=10.1
    Rc88 (Y2\#2315 Y2\#6) resistor r=701.957
    Rc89 (Y2\#2314 Y2\#2313) resistor r=2236.0317
    Rc25 (net3 net3\#2) resistor r=10.1
    Rd63 (Y2\#2315 Y2\#2314) resistor r=1644.8412
    Rd61 (Y2\#2314 Y2\#2317) resistor r=92.164
    Rc58 (QN\#7 QN\#2311) resistor r=3.116
    Rc27 (QN\#3 QN\#2311) resistor r=121570.4219
    Rd59 (Y2\#3 Y2\#4) resistor r=3908.8093
    Rd66 (SN\#6 SN) resistor r=90.8913
    Rc28 (Y1\#3 Y1) resistor r=1735.853
    Rd12 (RNi\#5 RNi\#4) resistor r=2244.8411
    Rd50 (Y2\#3 Y2\#2) resistor r=1723.2665
    Rd64 (Y2\#2 Y2\#5) resistor r=10.1
    Rc125 (SN\#9 SN) resistor r=7.2318
    Rd2 (SN\#2311 SN\#9) resistor r=80.464
    Rc116 (SN\#2311 SN\#2310) resistor r=1036.0317
    Rd3 (SN\#2311 SN\#2312) resistor r=2844.8411
    Rd54 (Y3\#6 Y3\#5) resistor r=1745.953
    Rd6 (Y3 Y3\#2311) resistor r=4.6937
    Rd55 (Y3\#2314 Y3\#2313) resistor r=219.2584
    Rc73 (Y3\#6 Y3\#2314) resistor r=1521.2155
    Rc59 (Y3\#2314 Y3\#2315) resistor r=3688.636
    Rd51 (VDD!\#3 VDD!\#23) resistor r=2.5488
    Rc70 (SN\#2 SN\#4) resistor r=1636.0317
    Rc5 (net14 net14\#2) resistor r=10.1
    Rd5 (SN\#1 SN\#2) resistor r=1336.0317
    Rd65 (SN\#2 SN) resistor r=85.564
    Rc118 (Q\#4 Q) resistor r=1151.5636
    Rc56 (QN\#3 QN) resistor r=543.3479
    Rc63 (VSS! VSS!\#8) resistor r=5.1322
    Rc67 (VSS! VSS!\#2314) resistor r=6.1438
    Rd33 (VDD! VDD!\#21) resistor r=2.7572
    Rd58 (VDD! VDD!\#20) resistor r=66.34m
    Rc85 (VDD!\#2315 VDD!\#2316) resistor r=189.6m
    Rc69 (Y3\#6 Y3\#7) resistor r=73.2063
    Rc74 (Y3\#6 Y3\#2310) resistor r=5.8565
    Rc117 (Q\#4 Q\#2311) resistor r=1642.5249
    Rc26 (QN\#2311 QN\#2310) resistor r=2.5
    Rd46 (VDD!\#9 VDD!\#29) resistor r=2.5488
    Rc82 (VDD!\#9 VDD!\#2310) resistor r=189.6m
    Rc104 (VDD!\#2310 VDD!\#31) resistor r=5.1621
    Rc83 (VDD!\#31 VDD!\#2312) resistor r=5.1621
    Rd48 (VDD!\#2310 VDD!\#2312) resistor r=130.8m
    Rd47 (VDD!\#2310 VDD!\#30) resistor r=2.5488
    Rc128 (Q\#4 Q\#5) resistor r=73.2063
    Rc120 (Q\#5 Q\#8) resistor r=2.7955
    Rc122 (Q\#4 Q\#8) resistor r=5.8565
    Rc129 (Q\#8 Q\#7) resistor r=2.5
    Rc121 (Q\#8 Q\#9) resistor r=2.7
    Rd68 (VDD!\#2312 VDD!\#32) resistor r=2.5488
    Rc105 (VDD!\#2312 VDD!\#2313) resistor r=106.2m
    Rc54 (QN QN\#2311) resistor r=1157.0509
    Rc55 (QN\#8 QN\#2311) resistor r=2.8852
    Rc119 (Q\#4 Q\#3) resistor r=123274.4219
    Rc16 (net9 net9\#2) resistor r=10.1
    Rd20 (VSS!\#2310 VSS!\#4) resistor r=22.1536
    Rc29 (net4 net4\#2) resistor r=10.1
    Rd22 (VSS!\#2 VSS!\#2310) resistor r=6.7931
    Rc39 (net5 net5\#2) resistor r=10.1
    Rc40 (net6 net6\#2) resistor r=10.1
    Rc72 (Y3\#2 Y3\#3) resistor r=3908.8093
    Rc90 (Y2\#2319 Y2\#2317) resistor r=80.464
    Rc47 (net11 net11\#2) resistor r=10.1
    Rc64 (VSS!\#2 VSS!\#9) resistor r=5.0974
    Rc50 (net12 net12\#2) resistor r=10.1
    Rc42 (CK\#7 CK\#5) resistor r=80.464
    Rc111 (Y2\#2319 Y2\#2318) resistor r=2236.0317
    Rd49 (Y2\#2319 Y2\#20) resistor r=1644.8412
    Rd25 (VSS!\#6 VSS!\#2314) resistor r=30.9033
    Rc8 (net7 net7\#2) resistor r=10.1
    Rc103 (VDD!\#28 VDD!\#9) resistor r=5.1621
    Rd29 (VDD!\#7 VDD!\#9) resistor r=130.8m
    Rc81 (VDD!\#7 VDD!\#28) resistor r=5.1621
    Rc53 (QN\#7 QN\#8) resistor r=38.95
    Rd28 (VDD!\#7 VDD!\#27) resistor r=2.5488
    Rc102 (VDD!\#6 VDD!\#7) resistor r=106.2m
    Rd26 (Y3\#2 Y3) resistor r=706.957
    Rd4 (Y3 Y3\#2310) resistor r=375.5m
    Rd56 (Y3\#7 Y3\#2310) resistor r=2.7955
    Rd31 (RN\#3 RN) resistor r=85.564
    Rc98 (RN\#3 RN\#4) resistor r=1036.0317
    Rc96 (net13\#6 net13\#7) resistor r=1636.0317
    Rd17 (RN\#2 RN\#3) resistor r=1936.0317
    Rd18 (net13\#3 net13\#4) resistor r=10.9636
    Rc76 (net13 net13\#3) resistor r=20.0823
    Rd32 (net13\#6 net13) resistor r=80.464
    Rd19 (net13\#5 net13\#6) resistor r=1336.0317
    Rc97 (net13 net13\#4) resistor r=10.5113
    Rc109 (VDD!\#20 VDD!\#40) resistor r=2.7224
    Rd70 (VDD!\#2313 VDD!\#2315) resistor r=130.8m
    Rc30 (Y1\#3 Y1\#2310) resistor r=1642.5249
    Rd27 (VDD!\#6 VDD!\#26) resistor r=2.5488
    Rc75 (Y3\#2310 Y3\#2311) resistor r=5.7769
    Rd53 (VDD!\#4 VDD!\#24) resistor r=2.5488
    Rd41 (Y4\#6 Y4\#7) resistor r=1044.8411
    Rc71 (Y3\#2310 Y3\#9) resistor r=2.5
    Rd10 (VDD!\#4 VDD!\#6) resistor r=130.8m
    Rc101 (VDD!\#4 VDD!\#25) resistor r=5.1621
    Rc80 (VDD!\#25 VDD!\#6) resistor r=5.1621
    Rc19 (Y4\#6 Y4\#8) resistor r=85.464
    Rc23 (Y4\#6 Y4\#5) resistor r=2836.0317
    Rc43 (CK\#7 CK\#8) resistor r=3444.8411
    Rc45 (CK\#7 CK\#6) resistor r=436.0318
    Rc62 (net2 net2\#2) resistor r=10.1
    Rc60 (net1 net1\#2) resistor r=10.1
    Rd69 (VDD!\#2313 VDD!\#33) resistor r=2.5488
    Rc84 (VDD!\#2313 VDD!\#34) resistor r=5.1621
    Rc106 (VDD!\#34 VDD!\#2315) resistor r=5.1621
    Rd60 (VDD!\#2315 VDD!\#35) resistor r=2.5488
    Rc112 (Y2\#6 Y2\#7) resistor r=72.1937
    Rc91 (Y2\#6 Y2\#2310) resistor r=5.7755
    Rc110 (Y2\#2 Y2) resistor r=1740.853
    Rd57 (VDD!\#39 VDD!\#20) resistor r=3.7878
    Rc87 (VDD!\#2318 VDD!\#20) resistor r=119.8m
    Rc33 (Y1\#3 Y1\#7) resistor r=5.8565
    Rc36 (Y1\#3 Y1\#4) resistor r=73.2063
    Rc113 (Y2\#2310 Y2\#9) resistor r=2.5
    Rd62 (Y2\#7 Y2\#2310) resistor r=2.7969
    Rd9 (Y2\#2310 Y2\#2311) resistor r=4.8053
    Rd7 (Y2 Y2\#2310) resistor r=456.5m
    Rc92 (Y2 Y2\#2311) resistor r=5.7062
    Rc31 (Y1\#2310 Y1\#9) resistor r=201.111
    Rc32 (Y1\#2310 Y1\#2311) resistor r=3744.2583
    Rd16 (VDD!\#2318 VDD!\#38) resistor r=2.5488
    Rc38 (Y1\#7 Y1\#8) resistor r=2.7
    Rc108 (VDD!\#2318 VDD!\#39) resistor r=9.9848
    Rd14 (VDD!\#2316 VDD!\#2318) resistor r=130.8m
    Rc86 (VDD!\#37 VDD!\#2318) resistor r=5.1621
    Rc107 (VDD!\#2316 VDD!\#37) resistor r=5.1621
    Rd15 (VDD!\#2316 VDD!\#36) resistor r=2.5488
    Rc34 (Y1\#4 Y1\#7) resistor r=2.7955
    Rc37 (Y1\#7 Y1\#6) resistor r=2.5
    MX57_M0_unmatched (net8\#2 SN\#8 VSS!\#2313 VSS!\#2313) nch w=2e-06 \
        l=1e-06 as=0 ad=5e-12 ps=0 pd=9e-06 sa=2e-06 sb=2e-06
    MX62_M0_unmatched (net10 RNi\#6 VSS!\#2312 VSS!\#2312) nch w=2e-06 \
        l=1e-06 as=0 ad=5e-12 ps=0 pd=9e-06 sa=2e-06 sb=2e-06
    MX63_M0_unmatched (net3\#2 Y2\#2313 VSS!\#2311 VSS!\#2311) nch w=2e-06 \
        l=1e-06 as=0 ad=5e-12 ps=0 pd=9e-06 sa=2e-06 sb=2e-06
    MX56_M0_unmatched (RNi\#2 SN\#4 net14 net14) nch w=2e-06 l=1e-06 as=0 \
        ad=5e-12 ps=0 pd=9e-06 sa=2e-06 sb=2e-06
    MX64_M0_unmatched (net4\#2 SN\#2310 net3 net3) nch w=2e-06 l=1e-06 \
        as=0 ad=5e-12 ps=0 pd=9e-06 sa=2e-06 sb=2e-06
    MX61_M0_unmatched (net9 CK\#3 net10\#2 net10\#2) nch w=2e-06 l=1e-06 \
        as=0 ad=5e-12 ps=0 pd=9e-06 sa=2e-06 sb=2e-06
    MX65_M0_unmatched (Q\#3 QN\#4 net4 net4) nch w=2e-06 l=1e-06 as=0 \
        ad=5e-12 ps=0 pd=9e-06 sa=2e-06 sb=2e-06
    MX66_M0_unmatched (QN\#6 Q\#2312 net5\#2 net5\#2) nch w=2e-06 l=1e-06 \
        as=0 ad=5e-12 ps=0 pd=9e-06 sa=2e-06 sb=2e-06
    MX55_M0_unmatched (net14\#2 net13\#7 VSS!\#2314 VSS!\#2314) nch \
        w=2e-06 l=1e-06 as=0 ad=5e-12 ps=0 pd=9e-06 sa=2e-06 sb=2e-06
    MX71_M0_unmatched (Y3\#5 Y4\#5 net12 net12) nch w=2e-06 l=1e-06 as=0 \
        ad=5e-12 ps=0 pd=9e-06 sa=2e-06 sb=2e-06
    MX74_M0_unmatched (net2 RNi\#2314 VSS!\#1 VSS!\#1) nch w=2e-06 l=1e-06 \
        as=0 ad=5e-12 ps=0 pd=9e-06 sa=2e-06 sb=2e-06
    MX68_M0_unmatched (net6 Y3\#3 VSS!\#2310 VSS!\#2310) nch w=2e-06 \
        l=1e-06 as=0 ad=5e-12 ps=0 pd=9e-06 sa=2e-06 sb=2e-06
    MX69_M0_unmatched (net11\#2 Y2\#2318 VSS!\#9 VSS!\#9) nch w=2e-06 \
        l=1e-06 as=0 ad=5e-12 ps=0 pd=9e-06 sa=2e-06 sb=2e-06
    MX54_M0_unmatched (net13\#3 RN\#4 VSS!\#8 VSS!\#8) nch w=2e-06 l=1e-06 \
        as=0 ad=5e-12 ps=0 pd=9e-06 sa=2e-06 sb=2e-06
    MX70_M0_unmatched (net12\#2 CK\#6 net11 net11) nch w=2e-06 l=1e-06 \
        as=0 ad=5e-12 ps=0 pd=9e-06 sa=2e-06 sb=2e-06
    MX67_M0_unmatched (net5 RNi\#2310 net6\#2 net6\#2) nch w=2e-06 l=1e-06 \
        as=0 ad=5e-12 ps=0 pd=9e-06 sa=2e-06 sb=2e-06
    MX73_M0_unmatched (net1 D\#4 net2\#2 net2\#2) nch w=2e-06 l=1e-06 as=0 \
        ad=5e-12 ps=0 pd=9e-06 sa=2e-06 sb=2e-06
    MX58_M0_unmatched (net7\#2 Y4 net8 net8) nch w=2e-06 l=1e-06 as=0 \
        ad=5e-12 ps=0 pd=9e-06 sa=2e-06 sb=2e-06
    MX72_M0_unmatched (Y4\#2311 Y3\#2315 net1\#2 net1\#2) nch w=2e-06 \
        l=1e-06 as=0 ad=5e-12 ps=0 pd=9e-06 sa=2e-06 sb=2e-06
    MX59_M0_unmatched (Y1\#2 Y2\#3 net7 net7) nch w=2e-06 l=1e-06 as=0 \
        ad=5e-12 ps=0 pd=9e-06 sa=2e-06 sb=2e-06
    MX60_M0_unmatched (Y2\#5 Y1\#2311 net9\#2 net9\#2) nch w=2e-06 l=1e-06 \
        as=0 ad=5e-12 ps=0 pd=9e-06 sa=2e-06 sb=2e-06
ends DFFSRX1_analog_extracted
// End of subcircuit definition.

// Library name: KISTA_SOI_STDLIB2
// Cell name: DFFX1
// View name: analog_extracted
subckt DFFX1_analog_extracted Q CK D QN
    C168 (VSS!\#9 Y2\#2311) capacitor c=191.082a
    C51 (VDD!\#1 D\#4) capacitor c=183.136a
    C55 (VDD!\#1 Y4\#9) capacitor c=112.844a
    C92 (VSS! CK) capacitor c=73.393a
    C110 (Y2\#9 CK) capacitor c=1.30624e-18
    C112 (Y2\#2313 CK) capacitor c=563.574a
    C114 (Y2\#2318 CK) capacitor c=21.9745a
    C121 (9 CK) capacitor c=14.6456f
    C141 (D\#4 VSS!) capacitor c=4.90928e-18
    C156 (Y4\#9 VSS!) capacitor c=4.35786e-18
    C173 (Y2\#2313 VSS!) capacitor c=44.6487a
    C174 (Y2\#2318 VSS!) capacitor c=5.39766e-19
    C193 (VSS!\#3 9) capacitor c=65.4157f
    C208 (Y4\#9 D\#4) capacitor c=771.126a
    C211 (D\#4 9) capacitor c=1.81104e-15
    C307 (Y2\#9 9) capacitor c=40.9597a
    C308 (Y2\#2313 9) capacitor c=23.2188f
    C309 (Y2\#2318 9) capacitor c=662.522a
    C5 (Q\#7 CK) capacitor c=594.754a
    C33 (Q\#7 9) capacitor c=3.46554e-15
    C6 (Q\#8 VSS!) capacitor c=15.6511a
    C25 (Y2\#9 Q\#8) capacitor c=1.26105e-18
    C27 (Y2\#2313 Q\#8) capacitor c=544.078a
    C30 (Y2\#2318 Q\#8) capacitor c=41.3263a
    C32 (Q\#8 9) capacitor c=3.77983e-15
    C3 (VDD!\#6 Q\#8) capacitor c=467.788a
    C50 (VDD!\#6 VSS!) capacitor c=38.8954a
    C78 (VDD!\#6 9) capacitor c=64.726f
    C7 (Q\#1 VSS!) capacitor c=9.62697e-18
    C35 (Q\#1 9) capacitor c=4.50794e-15
    C4 (VDD!\#8 Q\#1) capacitor c=427.31a
    C8 (Q\#2 VSS!) capacitor c=31.3269a
    C28 (Y2\#2313 Q\#2) capacitor c=67.538a
    C36 (Q\#2 9) capacitor c=811.341a
    C1 (Q\#2 VDD!\#2319) capacitor c=230.808a
    C9 (VSS!\#3 Q\#5) capacitor c=178.583a
    C34 (Q\#5 9) capacitor c=2.89073e-15
    C11 (Q\#8 QN) capacitor c=844.687a
    C15 (Q\#2 QN) capacitor c=256.994a
    C145 (QN VSS!) capacitor c=25.9177a
    C218 (Y2\#9 QN) capacitor c=7.1856e-19
    C220 (Y2\#2313 QN) capacitor c=310.022a
    C222 (Y2\#2318 QN) capacitor c=16.2282a
    C227 (9 QN) capacitor c=6.44939e-15
    C12 (QN\#2310 Q\#1) capacitor c=180.564a
    C24 (Y2\#9 Q) capacitor c=7.15267e-19
    C26 (Y2\#2313 Q) capacitor c=241.063a
    C29 (Y2\#2318 Q) capacitor c=7.07813e-19
    C31 (9 Q) capacitor c=1.88791e-15
    C148 (QN\#2310 VSS!) capacitor c=7.48979e-18
    C231 (QN\#2310 9) capacitor c=260.028a
    C38 (Q\#4 9) capacitor c=282.311a
    C2 (VDD!\#20 Q\#4) capacitor c=130.415a
    C48 (VDD!\#20 VSS!) capacitor c=33.3334a
    C13 (QN\#7 Q\#7) capacitor c=86.496a
    C14 (QN\#7 Q\#5) capacitor c=105.993a
    C99 (QN\#7 CK) capacitor c=200.507a
    C149 (QN\#7 VSS!) capacitor c=1.4987e-18
    C232 (QN\#7 9) capacitor c=705.553a
    C16 (Q\#2 QN\#5) capacitor c=196.025a
    C54 (VDD!\#2319 QN\#5) capacitor c=235.812a
    C146 (QN\#5 VSS!) capacitor c=3.9864e-18
    C228 (QN\#5 9) capacitor c=597.868a
    C86 (VDD!\#2319 X24_5) capacitor c=169.229a
    C43 (Q\#2 X24_5) capacitor c=436.112a
    C240 (QN\#5 X24_5) capacitor c=513.467a
    C20 (QN\#2 Q\#2) capacitor c=1.35919e-15
    C19 (QN\#2 Q\#8) capacitor c=3.00538e-19
    C150 (QN\#2 VSS!) capacitor c=1.70187e-18
    C219 (QN\#2 Y2\#9) capacitor c=1.3711e-18
    C221 (Y2\#2313 QN\#2) capacitor c=591.557a
    C223 (Y2\#2318 QN\#2) capacitor c=1.36058e-18
    C233 (QN\#2 9) capacitor c=4.49474e-15
    C18 (Q\#6 QN\#7) capacitor c=87.5393a
    C37 (Q\#6 9) capacitor c=665.791a
    C41 (net6\#2 Q\#5) capacitor c=130.436a
    C40 (net6\#2 Q\#7) capacitor c=110.892a
    C133 (net6\#2 CK) capacitor c=70.5043a
    C200 (net6\#2 VSS!) capacitor c=1.98222e-18
    C236 (QN\#7 net6\#2) capacitor c=47.9632a
    C359 (net6\#2 9) capacitor c=889.854a
    C22 (Y4\#7 Q\#7) capacitor c=586.666a
    C103 (Y4\#7 CK) capacitor c=1.51232e-15
    C201 (VSS!\#3 net6) capacitor c=180.714a
    C242 (Y2\#9 Y4\#7) capacitor c=4.46162e-18
    C244 (Y2\#2318 Y4\#7) capacitor c=74.1721a
    C262 (Y4\#7 9) capacitor c=28.5989f
    C358 (net6 9) capacitor c=448.517a
    C10 (VSS!\#5 Q\#6) capacitor c=114.174a
    C17 (Q\#6 QN\#4) capacitor c=86.496a
    C152 (VSS!\#5 QN\#4) capacitor c=217.739a
    C229 (QN\#4 9) capacitor c=1.15999e-15
    C21 (QN\#3 Q\#6) capacitor c=18.4731a
    C101 (QN\#3 CK) capacitor c=595.333a
    C151 (QN\#3 VSS!) capacitor c=4.46453e-18
    C234 (QN\#3 9) capacitor c=4.49534e-15
    C216 (QN\#2 Y4) capacitor c=293.75a
    C153 (Y4 VSS!) capacitor c=28.9466a
    C217 (QN\#3 Y4) capacitor c=293.961a
    C243 (Y2\#2313 Y4) capacitor c=2.24244e-15
    C100 (CK\#2 QN\#7) capacitor c=1.82522e-18
    C102 (QN\#3 CK\#2) capacitor c=7.66249e-18
    C96 (CK\#2 VSS!) capacitor c=6.48759e-18
    C104 (CK\#2 Y4) capacitor c=615.539a
    C111 (Y2\#9 CK\#2) capacitor c=8.43675e-21
    C113 (Y2\#2313 CK\#2) capacitor c=504.294a
    C115 (Y2\#2318 CK\#2) capacitor c=8.34883e-21
    C126 (CK\#2 9) capacitor c=5.52407e-15
    C23 (Q\#4 Y2\#8) capacitor c=258.467a
    C61 (VDD!\#20 Y2\#8) capacitor c=234.798a
    C164 (Y2\#8 VSS!) capacitor c=14.1133a
    C300 (Y2\#8 9) capacitor c=1.27273e-15
    C44 (Q\#4 X23_5) capacitor c=188.398a
    C317 (Y2\#8 X23_5) capacitor c=533.577a
    C87 (VDD!\#20 X23_5) capacitor c=162.469a
    C53 (QN\#2310 VDD!\#2318) capacitor c=206.238a
    C42 (Q\#8 X25_5) capacitor c=512.454a
    C85 (VDD!\#2318 X25_5) capacitor c=169.229a
    C239 (QN\#2310 X25_5) capacitor c=152.148a
    C238 (X25_5 QN) capacitor c=9.91316e-18
    C39 (Q\#6 net4) capacitor c=41.3514a
    C235 (QN\#4 net4) capacitor c=83.616a
    C198 (VSS!\#5 net4) capacitor c=73.2744a
    C356 (net4 9) capacitor c=234.991a
    C130 (net4\#2 CK) capacitor c=18.3381a
    C132 (CK\#2 net4\#2) capacitor c=2.36029e-19
    C199 (VSS!\#5 net4\#2) capacitor c=104.004a
    C357 (net4\#2 9) capacitor c=235.227a
    C47 (VDD!\#2317 VSS!) capacitor c=29.2353a
    C49 (VDD!\#21 VSS!) capacitor c=31.0123a
    C46 (VDD!\#21 CK\#4) capacitor c=235.822a
    C94 (CK\#4 VSS!) capacitor c=16.2759a
    C123 (CK\#4 9) capacitor c=2.55947e-15
    C52 (VDD!\#2317 QN\#8) capacitor c=130.415a
    C147 (QN\#8 VSS!) capacitor c=11.2116a
    C230 (QN\#8 9) capacitor c=282.075a
    C59 (VDD!\#2 Y4\#9) capacitor c=15.2914a
    C79 (VDD!\#1 X31_5) capacitor c=175.347a
    C215 (D\#4 X31_5) capacitor c=509.926a
    C275 (Y4\#9 X31_5) capacitor c=448.721a
    C213 (D\#2 9) capacitor c=4.29523e-15
    C62 (VDD!\#21 Y2\#2314) capacitor c=85.1701a
    C65 (VDD!\#2310 Y2\#2314) capacitor c=72.0822a
    C108 (Y2\#2314 CK\#4) capacitor c=410.094a
    C169 (Y2\#2314 VSS!) capacitor c=14.3906a
    C88 (VDD!\#21 X22_5) capacitor c=182.829a
    C140 (CK\#4 X22_5) capacitor c=511.921a
    C318 (Y2\#2314 X22_5) capacitor c=500.184a
    C63 (Y2\#2316 VDD!\#22) capacitor c=143.006a
    C66 (VDD!\#22 Y1\#7) capacitor c=235.79a
    C175 (Y1\#7 VSS!) capacitor c=10.548a
    C279 (Y2\#2316 Y1\#7) capacitor c=141.206a
    C322 (Y1\#7 9) capacitor c=617.267a
    C89 (VDD!\#22 X21_5) capacitor c=182.829a
    C319 (Y2\#2316 X21_5) capacitor c=318.488a
    C332 (Y1\#7 X21_5) capacitor c=504.842a
    C178 (Y1\#8 VSS!) capacitor c=9.26217e-19
    C248 (Y1\#8 Y4) capacitor c=22.5824a
    C327 (Y1\#8 9) capacitor c=435.479a
    C69 (Y1\#8 VDD!\#23) capacitor c=3.89199e-18
    C58 (VDD!\#2312 Y4\#4) capacitor c=239.793a
    C155 (Y4\#4 VSS!) capacitor c=2.23261e-18
    C259 (Y4\#4 9) capacitor c=2.0348e-15
    C64 (VDD!\#23 Y2\#5) capacitor c=235.625a
    C165 (Y2\#5 VSS!) capacitor c=5.8558e-18
    C289 (Y1\#8 Y2\#5) capacitor c=1.22492e-18
    C301 (Y2\#5 9) capacitor c=1.21937e-15
    C67 (VDD!\#23 Y1\#4) capacitor c=226.4a
    C246 (Y1\#4 Y4) capacitor c=288.196a
    C283 (Y1\#4 Y2\#5) capacitor c=256.868a
    C324 (Y1\#4 9) capacitor c=6.88362e-15
    C90 (VDD!\#23 X20_5) capacitor c=182.829a
    C320 (Y2\#5 X20_5) capacitor c=496.099a
    C333 (Y1\#4 X20_5) capacitor c=471.151a
    C171 (Y2\#2 VSS!) capacitor c=2.02844e-18
    C241 (Y2\#2 Y4) capacitor c=591.984a
    C286 (Y2\#2 Y1\#4) capacitor c=504.281a
    C290 (Y1\#8 Y2\#2) capacitor c=20.3537a
    C305 (Y2\#2 9) capacitor c=4.91545e-15
    C68 (Y1\#6 VDD!\#2312) capacitor c=121.044a
    C247 (Y1\#6 Y4\#4) capacitor c=162.408a
    C326 (Y1\#6 9) capacitor c=211.195a
    C282 (Y1\#4 Y2) capacitor c=686.86a
    C162 (Y2 VSS!) capacitor c=5.04183e-18
    C288 (Y1\#8 Y2) capacitor c=56.4699a
    C172 (Y2\#3 VSS!) capacitor c=7.55211e-18
    C306 (Y2\#3 9) capacitor c=4.05333e-15
    C176 (Y1\#9 VSS!) capacitor c=5.58079e-18
    C245 (Y1\#9 Y4) capacitor c=306.06a
    C323 (Y1\#9 9) capacitor c=2.68393e-15
    C91 (VDD!\#2312 X19_5) capacitor c=608.62a
    C334 (Y1\#6 X19_5) capacitor c=318.962a
    C278 (Y4\#4 X19_5) capacitor c=504.33a
    C159 (Y4\#2 VSS!) capacitor c=6.4659e-18
    C263 (Y4\#2 9) capacitor c=5.89446e-15
    C74 (VDD!\#2317 Y3) capacitor c=19.7488a
    C180 (Y3 VSS!) capacitor c=2.9973e-18
    C224 (Y3 QN) capacitor c=51.8762a
    C226 (Y3\#2 QN) capacitor c=152.093a
    C190 (Y3\#2 VSS!) capacitor c=6.47527e-18
    C255 (Y3\#2 Y4\#7) capacitor c=588.059a
    C292 (Y3\#2 Y2\#9) capacitor c=1.28223e-18
    C293 (Y2\#2313 Y3) capacitor c=101.723a
    C294 (Y2\#2313 Y3\#2) capacitor c=553.217a
    C295 (Y2\#2318 Y3\#2) capacitor c=42.0204a
    C341 (Y3\#2 9) capacitor c=5.3415e-15
    C191 (Y3\#8 VSS!) capacitor c=6.68224e-18
    C256 (Y3\#8 Y4\#7) capacitor c=27.348a
    C296 (Y3\#8 Y2\#9) capacitor c=1.71477e-18
    C297 (Y3\#8 Y2\#2313) capacitor c=638.111a
    C117 (CK\#7 Y2\#2313) capacitor c=7.27272e-19
    C97 (CK\#7 VSS!) capacitor c=4.62752e-19
    C105 (CK\#7 Y4\#7) capacitor c=42.52a
    C116 (CK\#7 Y2\#9) capacitor c=1.68565e-21
    C107 (Y2\#2311 CK) capacitor c=298.99a
    C109 (CK\#2 Y2\#2311) capacitor c=3.84828e-18
    C118 (CK\#7 Y2\#2318) capacitor c=5.5241e-20
    C127 (CK\#7 9) capacitor c=369.981a
    C298 (Y3\#8 Y2\#2318) capacitor c=56.1952a
    C303 (Y2\#2311 9) capacitor c=2.76793e-15
    C314 (net4\#2 Y2\#2311) capacitor c=83.616a
    C342 (Y3\#8 9) capacitor c=6.4954e-15
    C75 (VDD!\#2317 Y3\#4) capacitor c=234.798a
    C182 (Y3\#4 VSS!) capacitor c=12.3398a
    C225 (QN\#8 Y3\#4) capacitor c=189.659a
    C336 (Y3\#4 9) capacitor c=603.958a
    C119 (Y3\#3 CK) capacitor c=585.494a
    C338 (Y3\#3 9) capacitor c=3.1468e-15
    C343 (Y3\#3 net6) capacitor c=96.5184a
    C189 (VSS!\#8 Y3\#3) capacitor c=188.891a
    C84 (VDD!\#2317 X26_5) capacitor c=162.469a
    C237 (QN\#8 X26_5) capacitor c=188.398a
    C351 (Y3\#4 X26_5) capacitor c=510.168a
    C76 (VDD!\#2 Y3\#5) capacitor c=265.363a
    C184 (Y3\#5 VSS!) capacitor c=5.14198e-18
    C339 (Y3\#5 9) capacitor c=2.50294e-15
    C93 (CK\#6 VSS!) capacitor c=14.7215a
    C120 (Y3\#8 CK\#6) capacitor c=753.42a
    C122 (CK\#6 9) capacitor c=2.49965e-15
    C45 (VDD!\#2315 CK\#6) capacitor c=235.657a
    C72 (VDD!\#2315 Y3\#2311) capacitor c=102.009a
    C187 (Y3\#2311 VSS!) capacitor c=1.87456e-18
    C139 (CK\#6 X28_5) capacitor c=504.842a
    C82 (VDD!\#2315 X28_5) capacitor c=182.829a
    C349 (Y3\#2311 X28_5) capacitor c=314.368a
    C77 (VDD!\#4 Y3\#2311) capacitor c=68.6095a
    C188 (Y3\#9 VSS!) capacitor c=6.27241e-18
    C73 (Y3\#9 VDD!\#2316) capacitor c=182.411a
    C71 (Y3\#6 VDD!\#2314) capacitor c=178.527a
    C186 (Y3\#6 VSS!) capacitor c=15.8954a
    C56 (VDD!\#2313 Y4\#2312) capacitor c=112.853a
    C249 (Y4\#2312 Y3\#5) capacitor c=56.1602a
    C70 (VDD!\#2313 Y3\#2314) capacitor c=162.869a
    C181 (Y3\#2314 VSS!) capacitor c=8.59017e-18
    C253 (Y3\#6 Y4\#2312) capacitor c=160.13a
    C335 (Y3\#2314 9) capacitor c=2.35419e-15
    C80 (VDD!\#2313 X30_5) capacitor c=162.725a
    C276 (Y4\#2312 X30_5) capacitor c=162.853a
    C347 (Y3\#2314 X30_5) capacitor c=464.348a
    C160 (Y4\#2310 VSS!) capacitor c=32.6403a
    C209 (Y4\#2310 D\#2) capacitor c=8.29373e-18
    C257 (Y4\#2310 Y3\#2314) capacitor c=852.845a
    C183 (Y3\#2315 VSS!) capacitor c=8.01048e-18
    C337 (Y3\#2315 9) capacitor c=3.05742e-15
    C207 (Y4\#9 D) capacitor c=45.8825a
    C210 (9 D) capacitor c=1.44894e-15
    C142 (VSS!\#1 D) capacitor c=55.5743a
    C144 (D\#2 VSS!\#1) capacitor c=14.997a
    C143 (VSS!\#1 D\#3) capacitor c=131.959a
    C212 (D\#3 9) capacitor c=822.513a
    C57 (VDD!\#2314 Y4\#5) capacitor c=235.657a
    C154 (Y4\#5 VSS!) capacitor c=8.94266e-18
    C252 (Y3\#6 Y4\#5) capacitor c=712.564a
    C258 (Y4\#5 9) capacitor c=1.76792e-15
    C81 (VDD!\#2314 X29_5) capacitor c=162.849a
    C348 (Y3\#6 X29_5) capacitor c=336.739a
    C277 (Y4\#5 X29_5) capacitor c=519.508a
    C161 (VSS!\#3 Y4\#8) capacitor c=65.151a
    C260 (Y4\#8 9) capacitor c=2.11433e-15
    C60 (VDD!\#2316 Y2\#2317) capacitor c=235.657a
    C163 (Y2\#2317 VSS!) capacitor c=9.55564e-18
    C291 (Y3\#9 Y2\#2317) capacitor c=250.135a
    C299 (Y2\#2317 9) capacitor c=1.24698e-15
    C106 (Y2\#2319 CK) capacitor c=299.34a
    C302 (Y2\#2319 9) capacitor c=2.62339e-15
    C83 (VDD!\#2316 X27_5) capacitor c=182.829a
    C316 (Y2\#2317 X27_5) capacitor c=511.921a
    C350 (Y3\#9 X27_5) capacitor c=498.124a
    C98 (VSS!\#3 CK\#8) capacitor c=66.9436a
    C124 (CK\#8 9) capacitor c=1.42798e-15
    C137 (CK\#7 net11) capacitor c=6.92681e-19
    C134 (net11 CK) capacitor c=10.9286a
    C136 (net11\#2 CK) capacitor c=9.28575e-18
    C135 (CK\#8 net11) capacitor c=83.616a
    C202 (VSS!\#3 net11) capacitor c=73.7603a
    C203 (VSS!\#3 net11\#2) capacitor c=105.129a
    C315 (net11\#2 Y2\#2319) capacitor c=83.616a
    C360 (net11 9) capacitor c=296.558a
    C361 (net11\#2 9) capacitor c=235.172a
    C167 (VSS!\#7 Y2\#2319) capacitor c=187.388a
    C125 (CK\#3 9) capacitor c=1.35137e-15
    C131 (net4\#2 CK\#3) capacitor c=1.12473e-18
    C311 (Y2\#2311 net9) capacitor c=8.685e-19
    C128 (CK\#3 net9) capacitor c=92.2495a
    C197 (VSS!\#5 net9) capacitor c=179.845a
    C354 (net9 9) capacitor c=451.872a
    C129 (CK\#2 net9\#2) capacitor c=4.26612e-18
    C196 (net9\#2 VSS!) capacitor c=1.78488e-18
    C268 (net9\#2 Y4) capacitor c=13.1525a
    C313 (Y2\#3 net9\#2) capacitor c=2.13244e-18
    C331 (net9\#2 Y1\#9) capacitor c=110.831a
    C355 (net9\#2 9) capacitor c=891.726a
    C95 (VSS!\#2310 CK\#3) capacitor c=187.114a
    C179 (VSS!\#5 Y1) capacitor c=134.823a
    C138 (net12\#2 CK\#8) capacitor c=83.616a
    C366 (net12\#2 net11) capacitor c=39.8112a
    C214 (D\#3 net1) capacitor c=83.616a
    C267 (Y4\#2 net7\#2) capacitor c=1.04099e-18
    C264 (net7 Y4) capacitor c=3.42762e-18
    C265 (net7\#2 Y4) capacitor c=2.47154e-18
    C274 (Y4\#2310 net1) capacitor c=3.80737e-18
    C206 (VSS!\#1 net1) capacitor c=72.8241a
    C185 (VSS!\#1 Y3\#2312) capacitor c=133.001a
    C251 (Y4\#2313 Y3\#2312) capacitor c=64.1783a
    C157 (Y4\#2313 VSS!) capacitor c=7.05967e-18
    C166 (Y2\#4 VSS!) capacitor c=65.9122a
    C170 (Y2\#7 VSS!) capacitor c=10.4101a
    C177 (Y1\#2 VSS!) capacitor c=90.2294a
    C284 (Y1\#2 Y2\#4) capacitor c=80.8146a
    C285 (Y1\#2 Y2\#7) capacitor c=51.7266a
    C194 (net7 VSS!) capacitor c=72.6356a
    C310 (Y2\#4 net7) capacitor c=83.616a
    C329 (Y1\#2 net7) capacitor c=39.8112a
    C195 (net7\#2 VSS!) capacitor c=104.004a
    C158 (VSS!\#6 Y4\#3) capacitor c=190.717a
    C266 (net7\#2 Y4\#3) capacitor c=83.616a
    C250 (Y4\#2313 Y3\#2315) capacitor c=353.948a
    C261 (Y4\#3 9) capacitor c=2.17871e-15
    C304 (Y2\#4 9) capacitor c=813.887a
    C287 (Y2\#3 Y1\#2) capacitor c=16.2336a
    C325 (Y1\#2 9) capacitor c=221.343a
    C280 (Y2\#7 Y1) capacitor c=70.5541a
    C321 (9 Y1) capacitor c=2.52841e-15
    C328 (net7 Y1) capacitor c=1.50952e-18
    C340 (Y3\#2312 9) capacitor c=2.62186e-15
    C352 (net7 9) capacitor c=237.088a
    C353 (net7\#2 9) capacitor c=366.211a
    C364 (net1 9) capacitor c=253.121a
    C192 (VSS!\#3 Y3\#2313) capacitor c=77.1879a
    C344 (Y3\#2312 net12) capacitor c=1.50952e-18
    C204 (VSS!\#3 net12) capacitor c=72.6356a
    C205 (VSS!\#3 net12\#2) capacitor c=73.7811a
    C345 (Y3\#2313 net12) capacitor c=39.8112a
    C362 (net12 9) capacitor c=365.974a
    C363 (net12\#2 9) capacitor c=237.325a
    C365 (net1\#2 9) capacitor c=253.375a
    C273 (Y4\#2313 net1\#2) capacitor c=49.8475a
    C346 (net1\#2 Y3\#2315) capacitor c=83.616a
    C272 (net1\#2 Y4\#8) capacitor c=1.12473e-18
    C254 (Y3\#2313 Y4\#8) capacitor c=80.8146a
    C269 (Y4\#8 net12) capacitor c=83.616a
    C270 (Y4\#7 net12) capacitor c=3.99902e-18
    C271 (net12\#2 Y4\#7) capacitor c=3.42859e-18
    C281 (Y2\#7 Y1\#9) capacitor c=80.8146a
    C330 (net9\#2 Y1) capacitor c=142.353a
    C312 (Y2\#7 net9\#2) capacitor c=46.0379a
    MX36_M0_unmatched (net4\#2 Y2\#2311 VSS!\#9 VSS!\#9) nch w=2e-06 \
        l=1e-06 as=0 ad=5e-12 ps=0 pd=9e-06 sa=2e-06 sb=2e-06
    MX38_M0_unmatched (QN\#7 Q\#7 net6\#2 net6\#2) nch w=2e-06 l=1e-06 \
        as=0 ad=5e-12 ps=0 pd=9e-06 sa=2e-06 sb=2e-06
    MX37_M0_unmatched (Q\#6 QN\#4 net4 net4) nch w=2e-06 l=1e-06 as=0 \
        ad=5e-12 ps=0 pd=9e-06 sa=2e-06 sb=2e-06
    MX39_M0_unmatched (net6 Y3\#3 VSS!\#8 VSS!\#8) nch w=2e-06 l=1e-06 \
        as=0 ad=5e-12 ps=0 pd=9e-06 sa=2e-06 sb=2e-06
    MX40_M0_unmatched (net11\#2 Y2\#2319 VSS!\#7 VSS!\#7) nch w=2e-06 \
        l=1e-06 as=0 ad=5e-12 ps=0 pd=9e-06 sa=2e-06 sb=2e-06
    MX35_M0_unmatched (net9 CK\#3 VSS!\#2310 VSS!\#2310) nch w=2e-06 \
        l=1e-06 as=0 ad=5e-12 ps=0 pd=9e-06 sa=2e-06 sb=2e-06
    MX41_M0_unmatched (net12\#2 CK\#8 net11 net11) nch w=2e-06 l=1e-06 \
        as=0 ad=5e-12 ps=0 pd=9e-06 sa=2e-06 sb=2e-06
    MX44_M0_unmatched (net1 D\#3 VSS!\#1 VSS!\#1) nch w=2e-06 l=1e-06 as=0 \
        ad=5e-12 ps=0 pd=9e-06 sa=2e-06 sb=2e-06
    MX33_M0_unmatched (Y1\#2 Y2\#4 net7 net7) nch w=2e-06 l=1e-06 as=0 \
        ad=5e-12 ps=0 pd=9e-06 sa=2e-06 sb=2e-06
    MX32_M0_unmatched (net7\#2 Y4\#3 VSS!\#6 VSS!\#6) nch w=2e-06 l=1e-06 \
        as=0 ad=5e-12 ps=0 pd=9e-06 sa=2e-06 sb=2e-06
    MX43_M0_unmatched (Y4\#2313 Y3\#2315 net1\#2 net1\#2) nch w=2e-06 \
        l=1e-06 as=0 ad=5e-12 ps=0 pd=9e-06 sa=2e-06 sb=2e-06
    MX42_M0_unmatched (Y3\#2313 Y4\#8 net12 net12) nch w=2e-06 l=1e-06 \
        as=0 ad=5e-12 ps=0 pd=9e-06 sa=2e-06 sb=2e-06
    MX34_M0_unmatched (Y2\#7 Y1\#9 net9\#2 net9\#2) nch w=2e-06 l=1e-06 \
        as=0 ad=5e-12 ps=0 pd=9e-06 sa=2e-06 sb=2e-06
    Rd13 (Y2\#9 Y2\#2313) resistor r=85.8581
    Rc37 (Y2\#9 Y2\#2318) resistor r=37433.4531
    Rc32 (Y2\#2318 Y2\#2313) resistor r=86.7622
    Rs1 (9 VSS!) resistor r=50
    Rd5 (Q\#7 Q\#8) resistor r=3000
    Rd16 (Q\#8 Q\#1) resistor r=1123.2664
    Rc65 (VDD!\#6 VDD!\#8) resistor r=0.202
    Rd17 (Q\#1 Q\#2) resistor r=23.1127
    Rc20 (VDD!\#8 VDD!\#2319) resistor r=2.6224
    Rc69 (Q\#7 Q\#5) resistor r=476.9571
    Rd18 (Q\#1 Q) resistor r=3.2629
    Rc68 (QN QN\#2310) resistor r=2.854
    Rc58 (Q Q\#2) resistor r=3.199
    Rc70 (Q Q\#4) resistor r=2.675
    Rd19 (VDD!\#8 VDD!\#20) resistor r=7.9861
    Rd7 (QN\#2 QN\#5) resistor r=736.0318
    Rd8 (QN\#2 QN\#2310) resistor r=5555.1206
    Rc67 (QN\#2 QN) resistor r=414.5314
    Rc57 (Q\#5 Q\#6) resistor r=10.2
    Rc19 (net6 net6\#2) resistor r=10.1779
    Rc14 (VSS! VSS!\#5) resistor r=0.233
    Rc11 (VSS!\#3 VSS!\#5) resistor r=300.4m
    Rd4 (QN\#3 QN\#4) resistor r=436.0318
    Rc78 (QN\#2 QN\#3) resistor r=2372.0635
    Rc56 (QN\#3 QN\#7) resistor r=90.664
    Rc72 (CK\#2 CK) resistor r=86.564
    Rc53 (Y4 Y4\#7) resistor r=2
    Rc23 (Y2\#8 Y2\#9) resistor r=1336.0317
    Rd21 (VDD!\#20 VDD!\#2310) resistor r=3.9531
    Rc2 (VDD!\#8 VDD!\#2310) resistor r=99.5m
    Rd22 (VDD!\#2318 VDD!\#8) resistor r=8.0261
    Rd37 (VDD!\#6 VDD!\#2318) resistor r=3.9931
    Rc8 (net4 net4\#2) resistor r=10.1
    Rc77 (VDD!\#6 VDD!\#2317) resistor r=2.6224
    Rd23 (VDD!\#2310 VDD!\#21) resistor r=2.6224
    Rd30 (CK\#2 CK\#4) resistor r=2536.0317
    Rd6 (QN\#8 QN) resistor r=2.675
    Rd3 (VDD!\#1 VDD!\#2) resistor r=2.7628
    Rc74 (D\#2 D\#4) resistor r=1936.0317
    Rd33 (Y2\#2313 Y2\#2314) resistor r=3.0041
    Rd35 (Y2\#2314 Y2\#2316) resistor r=30.0947
    Rc31 (Y2\#2313 Y2\#2316) resistor r=3.0642
    Rd20 (VDD!\#2310 VDD!\#22) resistor r=10.6151
    Rc21 (VDD! VDD!\#2310) resistor r=133.6m
    Rc22 (VDD! VDD!\#22) resistor r=3.5266
    Rd39 (Y1\#7 Y1\#8) resistor r=736.0318
    Rd27 (VDD! VDD!\#23) resistor r=2.6083
    Rc75 (VDD! VDD!\#2312) resistor r=2.7238
    Rd41 (Y1\#8 Y1\#4) resistor r=172.4512
    Rc25 (Y2\#2 Y2\#5) resistor r=1336.0317
    Rd29 (Y1\#4 Y1\#6) resistor r=5.1243
    Rd25 (Y2\#2 Y2) resistor r=85.464
    Rc35 (Y2 Y2\#2313) resistor r=298.1m
    Rc24 (Y2\#2 Y2\#3) resistor r=1772.0636
    Rc61 (Y1\#8 Y1\#6) resistor r=175.9002
    Rc60 (Y1\#9 Y1\#8) resistor r=2236.0317
    Rc44 (Y4\#2 Y4\#4) resistor r=1936.0317
    Rc40 (Y4\#2 Y4) resistor r=85.464
    Rd9 (Y3\#2 Y3) resistor r=85.464
    Rc39 (Y3 Y3\#8) resistor r=198.1m
    Rd26 (Y2\#9 Y2\#2311) resistor r=2236.0317
    Rd31 (CK\#7 CK) resistor r=85.564
    Rd11 (Y3\#2 Y3\#4) resistor r=736.0318
    Rc33 (Y3\#2 Y3\#3) resistor r=2836.0317
    Rc17 (VSS!\#3 VSS!\#8) resistor r=5.0974
    Rc43 (Y3\#5 Y3\#8) resistor r=6.7751
    Rd32 (CK\#6 CK\#7) resistor r=2536.0317
    Rd44 (Y3\#8 Y3\#2311) resistor r=2.8622
    Rc64 (VDD!\#4 VDD!\#2315) resistor r=2.6224
    Rd43 (Y3\#2311 Y3\#9) resistor r=46.3
    Rc76 (VDD!\#2 VDD!\#4) resistor r=133.3m
    Rc66 (VDD!\#4 VDD!\#6) resistor r=133.3m
    Rd38 (VDD!\#2316 VDD!\#6) resistor r=3.5176
    Rd36 (VDD!\#4 VDD!\#2316) resistor r=10.6948
    Rd1 (VDD!\#2314 VDD!\#4) resistor r=3.5176
    Rd2 (VDD!\#2 VDD!\#2314) resistor r=10.6948
    Rc63 (VDD!\#2 VDD!\#2313) resistor r=2.7224
    Rc41 (Y3\#8 Y3\#9) resistor r=2.8061
    Rd12 (Y3\#6 Y3\#8) resistor r=3.3211
    Rd10 (Y3\#5 Y3\#6) resistor r=30.7388
    Rd34 (Y3\#2314 Y3\#5) resistor r=476.9571
    Rc48 (Y4\#2310 Y4\#2312) resistor r=2.6731
    Rc34 (Y3\#2314 Y3\#2315) resistor r=2400
    Rc47 (Y4\#7 Y4\#2310) resistor r=0.279
    Rc54 (Y4\#2310 Y4\#9) resistor r=2.9325
    Rc62 (D\#2 D) resistor r=85.564
    Rd28 (D\#2 D\#3) resistor r=436.0318
    Rc16 (VSS!\#1 VSS!\#3) resistor r=5.5725
    Rc51 (Y4\#5 Y4\#6) resistor r=1936.0317
    Rc52 (Y4\#6 Y4\#7) resistor r=85.464
    Rc46 (Y4\#6 Y4\#8) resistor r=1636.0317
    Rd15 (Y2\#2318 Y2\#2317) resistor r=1336.0317
    Rc30 (Y2\#2318 Y2\#2319) resistor r=2236.0317
    Rc59 (CK\#7 CK\#8) resistor r=1036.0317
    Rc26 (net11 net11\#2) resistor r=10.1
    Rc15 (VSS!\#1 VSS!\#7) resistor r=869.3669
    Rc13 (VSS!\#7 VSS!\#3) resistor r=5.1603
    Rc71 (CK\#2 CK\#3) resistor r=1036.0317
    Rc7 (net9 net9\#2) resistor r=10.1779
    Rc9 (VSS!\#5 VSS!\#2310) resistor r=5.0974
    Rc10 (VSS!\#9 VSS!\#5) resistor r=5.7562
    Rc18 (VSS!\#3 VSS!\#9) resistor r=46.8634
    Rd42 (Y4\#2 Y4\#3) resistor r=1636.0317
    Rc50 (Y4\#2310 Y4\#2313) resistor r=8.0786
    Rc49 (VSS! VSS!\#6) resistor r=5.0972
    Rc1 (net7 net7\#2) resistor r=10.1
    Rc36 (Y3\#2315 Y3\#2312) resistor r=476.9571
    Rd24 (Y2\#3 Y2\#4) resistor r=436.0318
    Rd14 (Y2\#3 Y2\#7) resistor r=90.564
    Rc73 (Y1 Y1\#2) resistor r=10.1
    Rc42 (Y3\#2312 Y3\#2313) resistor r=10.1
    Rc38 (net1 net1\#2) resistor r=10.1
    Rc55 (Y4\#7 Y4\#2313) resistor r=15.082
    Rc29 (net12 net12\#2) resistor r=10.1
    Rd40 (Y1\#9 Y1) resistor r=476.9571
    MX31_M0_unmatched (Y4\#9 D\#4 VDD!\#1 VDD!\#1) pch w=4e-06 l=1e-06 \
        as=0 ad=1e-11 ps=0 pd=1.3e-05 sa=2e-06 sb=2e-06
    MX24_M0_unmatched (Q\#2 QN\#5 VDD!\#2319 VDD!\#2319) pch w=4e-06 \
        l=1e-06 as=0 ad=1e-11 ps=0 pd=1.3e-05 sa=2e-06 sb=2e-06
    MX23_M0_unmatched (Q\#4 Y2\#8 VDD!\#20 VDD!\#20) pch w=4e-06 l=1e-06 \
        as=0 ad=1e-11 ps=0 pd=1.3e-05 sa=2e-06 sb=2e-06
    MX25_M0_unmatched (QN\#2310 Q\#8 VDD!\#2318 VDD!\#2318) pch w=4e-06 \
        l=1e-06 as=0 ad=1e-11 ps=0 pd=1.3e-05 sa=2e-06 sb=2e-06
    MX22_M0_unmatched (Y2\#2314 CK\#4 VDD!\#21 VDD!\#21) pch w=4e-06 \
        l=1e-06 as=0 ad=1e-11 ps=0 pd=1.3e-05 sa=2e-06 sb=2e-06
    MX21_M0_unmatched (Y2\#2316 Y1\#7 VDD!\#22 VDD!\#22) pch w=4e-06 \
        l=1e-06 as=0 ad=1e-11 ps=0 pd=1.3e-05 sa=2e-06 sb=2e-06
    MX20_M0_unmatched (Y1\#4 Y2\#5 VDD!\#23 VDD!\#23) pch w=4e-06 l=1e-06 \
        as=0 ad=1e-11 ps=0 pd=1.3e-05 sa=2e-06 sb=2e-06
    MX19_M0_unmatched (Y1\#6 Y4\#4 VDD!\#2312 VDD!\#2312) pch w=4e-06 \
        l=1e-06 as=0 ad=1e-11 ps=0 pd=1.3e-05 sa=2e-06 sb=2e-06
    MX26_M0_unmatched (QN\#8 Y3\#4 VDD!\#2317 VDD!\#2317) pch w=4e-06 \
        l=1e-06 as=0 ad=1e-11 ps=0 pd=1.3e-05 sa=2e-06 sb=2e-06
    MX28_M0_unmatched (Y3\#2311 CK\#6 VDD!\#2315 VDD!\#2315) pch w=4e-06 \
        l=1e-06 as=0 ad=1e-11 ps=0 pd=1.3e-05 sa=2e-06 sb=2e-06
    MX30_M0_unmatched (Y4\#2312 Y3\#2314 VDD!\#2313 VDD!\#2313) pch \
        w=4e-06 l=1e-06 as=0 ad=1e-11 ps=0 pd=1.3e-05 sa=2e-06 sb=2e-06
    MX29_M0_unmatched (Y3\#6 Y4\#5 VDD!\#2314 VDD!\#2314) pch w=4e-06 \
        l=1e-06 as=0 ad=1e-11 ps=0 pd=1.3e-05 sa=2e-06 sb=2e-06
    MX27_M0_unmatched (Y3\#9 Y2\#2317 VDD!\#2316 VDD!\#2316) pch w=4e-06 \
        l=1e-06 as=0 ad=1e-11 ps=0 pd=1.3e-05 sa=2e-06 sb=2e-06
ends DFFX1_analog_extracted
// End of subcircuit definition.

// Library name: KISTA_SOI_STDLIB2
// Cell name: INVX1
// View name: analog_extracted
subckt INVX1_analog_extracted Y A
    Rc3 (Y Y\#2) resistor r=2.875
    Rd1 (A\#2 A\#3) resistor r=1336.0317
    Rd3 (A\#3 A) resistor r=85.564
    Rc2 (Y Y\#1) resistor r=5.3
    Rc1 (A\#3 A\#4) resistor r=2236.0317
    Rc4 (VDD!\#1 VDD!) resistor r=2.6184
    Rc5 (VSS! VSS!\#1) resistor r=5.1322
    Rs1 (1 VSS!) resistor r=50
    C3 (Y\#2 A\#2) capacitor c=260.27a
    C7 (VDD!\#1 Y\#2) capacitor c=140.489a
    C16 (VDD!\#1 A\#2) capacitor c=205.865a
    C2 (Y\#2 A) capacitor c=81.5736a
    C15 (VDD!\#1 A) capacitor c=7.37798e-18
    C1 (A Y) capacitor c=448.073a
    C5 (A\#3 Y) capacitor c=30.3526a
    C17 (A\#3 VDD!\#1) capacitor c=4.67634e-19
    C8 (1 Y) capacitor c=2.79283e-15
    C9 (Y\#2 1) capacitor c=1.34766e-15
    C11 (Y\#2 X1_5) capacitor c=408.586a
    C10 (Y\#1 1) capacitor c=1.42082e-15
    C18 (1 A) capacitor c=6.29836e-15
    C19 (A\#2 1) capacitor c=1.22893e-15
    C22 (A\#2 X1_5) capacitor c=507.931a
    C21 (A\#3 1) capacitor c=353.49a
    C4 (Y\#1 A\#4) capacitor c=310.409a
    C20 (A\#4 1) capacitor c=2.74859e-15
    C26 (VDD!\#1 1) capacitor c=111.283a
    C28 (VDD!\#1 X1_5) capacitor c=408.586a
    C27 (X1_5 VDD!) capacitor c=30.6619a
    C25 (1 VDD!) capacitor c=5.52148e-15
    C6 (Y\#1 VSS!) capacitor c=106.639a
    C14 (VSS!\#1 A\#4) capacitor c=169.277a
    C12 (VSS! A) capacitor c=1.06321e-18
    C13 (VSS!\#1 A) capacitor c=2.17386e-18
    C23 (1 VSS!) capacitor c=2.98884e-15
    C24 (VSS!\#1 1) capacitor c=2.9186e-15
    MX0_M0_unmatched (Y\#1 A\#4 VSS!\#1 VSS!\#1) nch w=2e-06 l=1e-06 as=0 \
        ad=5e-12 ps=0 pd=9e-06 sa=2e-06 sb=2e-06
    MX1_M0_unmatched (Y\#2 A\#2 VDD!\#1 VDD!\#1) pch w=4e-06 l=1e-06 as=0 \
        ad=1e-11 ps=0 pd=1.3e-05 sa=2e-06 sb=2e-06
ends INVX1_analog_extracted
// End of subcircuit definition.

// Library name: KISTA_SOI_STDLIB2
// Cell name: NAND2X1
// View name: analog_extracted
subckt NAND2X1_analog_extracted Y A B
    C2 (Y\#1 VDD!\#1) capacitor c=177.934a
    C10 (Y\#1 B\#4) capacitor c=870.028a
    C14 (Y\#1 3) capacitor c=2.12102e-15
    C34 (VDD!\#1 B\#4) capacitor c=236.854a
    C36 (VDD!\#1 3) capacitor c=4.52721e-15
    C50 (B\#4 3) capacitor c=2.37805e-15
    C12 (3 Y) capacitor c=2.99864e-15
    C7 (B Y) capacitor c=481.841a
    C49 (3 B) capacitor c=6.65448e-15
    C8 (Y\#4 B) capacitor c=86.486a
    C13 (Y\#4 3) capacitor c=1.66492e-15
    C1 (Y\#4 VSS!) capacitor c=80.1506a
    C25 (B VSS!) capacitor c=8.00924e-18
    C26 (B\#4 VSS!) capacitor c=2.09596e-18
    C28 (3 VSS!) capacitor c=9.95935e-15
    C4 (Y\#4 A) capacitor c=6.94644e-18
    C20 (A VSS!) capacitor c=12.4438a
    C41 (B A) capacitor c=23.9904a
    C43 (3 A) capacitor c=6.60898e-15
    C6 (A\#3 Y\#4) capacitor c=4.39203e-19
    C42 (A\#3 B) capacitor c=1.00493e-18
    C46 (A\#3 3) capacitor c=367.049a
    C22 (VSS!\#1 A) capacitor c=53.1668a
    C24 (A\#3 VSS!\#1) capacitor c=3.74305e-18
    C29 (VSS!\#1 3) capacitor c=393.103a
    C9 (Y\#4 B\#6) capacitor c=171.592a
    C27 (B\#6 VSS!) capacitor c=68.7581a
    C51 (B\#6 3) capacitor c=1.44819e-15
    C11 (B\#5 Y) capacitor c=6.01974e-19
    C15 (Y\#3 3) capacitor c=80.2896a
    C52 (B\#5 3) capacitor c=7.03308e-18
    C55 (B\#4 X5_5) capacitor c=509.926a
    C17 (Y\#1 X5_5) capacitor c=463.313a
    C38 (VDD!\#1 X5_5) capacitor c=448.721a
    C35 (3 VDD!) capacitor c=5.62318e-15
    C53 (net1 B) capacitor c=12.9426a
    C16 (Y\#4 net1) capacitor c=46.0379a
    C54 (B\#6 net1) capacitor c=83.616a
    C30 (net1 VSS!) capacitor c=72.6356a
    C56 (net1 3) capacitor c=276.694a
    C31 (net1\#2 VSS!) capacitor c=63.125a
    C32 (VSS!\#1 net1\#2) capacitor c=39.1322a
    C57 (net1\#2 3) capacitor c=358.532a
    C3 (Y\#3 VDD!\#2) capacitor c=141.374a
    C19 (VDD!\#2 VSS!) capacitor c=6.25475e-18
    C21 (A\#2 VSS!) capacitor c=4.91066e-18
    C5 (Y\#3 A\#2) capacitor c=161.337a
    C33 (VDD!\#2 A\#2) capacitor c=239.793a
    C37 (VDD!\#2 3) capacitor c=56.6244a
    C44 (A\#2 3) capacitor c=3.45581e-15
    C45 (A\#4 3) capacitor c=752.34a
    C23 (VSS!\#1 A\#4) capacitor c=169.84a
    C47 (net1\#2 A\#4) capacitor c=83.616a
    C39 (X4_5 VDD!) capacitor c=36.7943a
    C18 (Y\#3 X4_5) capacitor c=449.345a
    C40 (VDD!\#2 X4_5) capacitor c=448.721a
    C48 (A\#2 X4_5) capacitor c=504.33a
    MX5_M0_unmatched (Y\#1 B\#4 VDD!\#1 VDD!\#1) pch w=4e-06 l=1e-06 as=0 \
        ad=1e-11 ps=0 pd=1.3e-05 sa=2e-06 sb=2e-06
    MX4_M0_unmatched (Y\#3 A\#2 VDD!\#2 VDD!\#2) pch w=4e-06 l=1e-06 as=0 \
        ad=1e-11 ps=0 pd=1.3e-05 sa=2e-06 sb=2e-06
    Rd5 (Y Y\#1) resistor r=3.3533
    Rc4 (Y Y\#4) resistor r=5.3
    Rs1 (3 VSS!) resistor r=50
    Rc7 (A\#3 A) resistor r=85.5515
    Rc13 (VSS!\#1 VSS!) resistor r=5.0867
    Rd1 (Y Y\#3) resistor r=3.4204
    Rd4 (B\#4 B\#5) resistor r=2536.0317
    Rc5 (Y\#1 Y\#3) resistor r=19.8455
    Rc11 (VDD!\#1 VDD!) resistor r=2.7298
    Rd6 (B\#5 B) resistor r=85.5671
    Rc2 (B\#5 B\#6) resistor r=1036.0317
    Rc6 (net1 net1\#2) resistor r=10.1
    Rd3 (A\#3 A\#4) resistor r=436.0318
    Rc9 (A\#2 A\#3) resistor r=3136.0317
    Rc12 (VDD! VDD!\#2) resistor r=2.6222
    MX3_M0_unmatched (Y\#4 B\#6 net1 net1) nch w=2e-06 l=1e-06 as=0 \
        ad=5e-12 ps=0 pd=9e-06 sa=2e-06 sb=2e-06
    MX2_M0_unmatched (net1\#2 A\#4 VSS!\#1 VSS!\#1) nch w=2e-06 l=1e-06 \
        as=0 ad=5e-12 ps=0 pd=9e-06 sa=2e-06 sb=2e-06
ends NAND2X1_analog_extracted
// End of subcircuit definition.

// Library name: KISTA_SOI_STDLIB2
// Cell name: NOR2X1
// View name: analog_extracted
subckt NOR2X1_analog_extracted Y A B
    C12 (Y\#3 B\#2) capacitor c=329.679a
    C16 (Y\#3 3) capacitor c=1.55622e-15
    C19 (Y\#3 net1) capacitor c=82.8682a
    C53 (B\#2 3) capacitor c=1.92029e-15
    C57 (B\#2 net1) capacitor c=139.36a
    C61 (net1 3) capacitor c=210.796a
    C3 (Y\#3 VDD!) capacitor c=71.0989a
    C37 (B\#2 VDD!) capacitor c=66.3a
    C38 (3 VDD!) capacitor c=5.18606e-15
    C40 (net1 VDD!) capacitor c=76.8452a
    C5 (Y\#3 A\#2) capacitor c=6.22477e-18
    C47 (A\#2 3) capacitor c=2.75034e-15
    C11 (Y\#3 B) capacitor c=16.3017a
    C52 (3 B) capacitor c=6.43713e-15
    C56 (net1 B) capacitor c=2.95248e-18
    C9 (B Y) capacitor c=470.317a
    C15 (3 Y) capacitor c=4.68539e-15
    C20 (Y\#3 X3_5) capacitor c=437.88a
    C60 (B\#2 X3_5) capacitor c=526.868a
    C63 (X3_5 net1) capacitor c=318.997a
    C35 (X3_5 VSS!) capacitor c=6.13238e-18
    C21 (VDD! VSS!) capacitor c=11.3334a
    C23 (A\#2 VSS!) capacitor c=1.20595e-18
    C27 (B VSS!) capacitor c=7.48425e-18
    C28 (B\#2 VSS!) capacitor c=2.20211e-18
    C14 (B\#3 Y) capacitor c=30.843a
    C30 (B\#3 VSS!) capacitor c=4.7437e-19
    C31 (3 VSS!) capacitor c=6.71909e-15
    C55 (B\#3 3) capacitor c=364.137a
    C59 (B\#3 net1) capacitor c=1.87135e-19
    C34 (net1\#2 VSS!) capacitor c=4.51202e-19
    C41 (net1\#2 VDD!) capacitor c=10.97a
    C36 (VDD!\#1 A\#2) capacitor c=239.843a
    C39 (VDD!\#1 3) capacitor c=4.95179e-15
    C42 (VDD!\#1 net1\#2) capacitor c=133.602a
    C50 (net1\#2 A\#2) capacitor c=139.36a
    C58 (net1\#2 B) capacitor c=2.26325e-18
    C62 (net1\#2 3) capacitor c=79.3505a
    C10 (B\#4 Y) capacitor c=726.629a
    C54 (B\#4 3) capacitor c=1.94237e-15
    C43 (VDD!\#1 X2_5) capacitor c=474.675a
    C64 (net1\#2 X2_5) capacitor c=318.905a
    C51 (A\#2 X2_5) capacitor c=503.459a
    C26 (A\#3 VSS!) capacitor c=8.24273e-19
    C45 (A\#3 B) capacitor c=6.21617e-18
    C49 (A\#3 3) capacitor c=378.814a
    C1 (VSS!\#3 Y) capacitor c=56.7029a
    C29 (VSS!\#3 B\#4) capacitor c=185.195a
    C17 (Y\#4 3) capacitor c=354.426a
    C32 (VSS!\#3 3) capacitor c=227.131a
    C33 (VSS!\#2 3) capacitor c=3.74739e-15
    C2 (Y\#2 VSS!) capacitor c=243.467a
    C8 (A\#3 Y\#2) capacitor c=3.29722e-18
    C13 (Y\#2 B) capacitor c=8.70551e-18
    C44 (B A) capacitor c=98.0741a
    C4 (A Y) capacitor c=5.27205e-18
    C6 (Y\#2 A) capacitor c=103.152a
    C18 (Y\#2 3) capacitor c=1.33868e-15
    C22 (A VSS!) capacitor c=13.0048a
    C24 (VSS!\#2 A) capacitor c=39.291a
    C46 (3 A) capacitor c=6.65615e-15
    C48 (A\#4 3) capacitor c=1.44419e-15
    C7 (Y\#2 A\#4) capacitor c=169.195a
    C25 (VSS!\#2 A\#4) capacitor c=191.411a
    MX5_M0_unmatched (Y\#4 B\#4 VSS!\#3 VSS!\#3) nch w=2e-06 l=1e-06 as=0 \
        ad=5e-12 ps=0 pd=9e-06 sa=2e-06 sb=2e-06
    MX4_M0_unmatched (Y\#2 A\#4 VSS!\#2 VSS!\#2) nch w=2e-06 l=1e-06 as=0 \
        ad=5e-12 ps=0 pd=9e-06 sa=2e-06 sb=2e-06
    Rd1 (Y Y\#3) resistor r=2.875
    Rc5 (B\#2 B\#3) resistor r=1936.0317
    Rc2 (net1 net1\#2) resistor r=5.05
    Rc11 (VDD! VDD!\#1) resistor r=2.7238
    Rc1 (B\#3 B) resistor r=85.564
    Rd6 (B\#3 B\#4) resistor r=1636.0317
    Rs1 (3 VSS!) resistor r=50
    Rd2 (A\#2 A\#3) resistor r=2536.0317
    Rd5 (VSS! VSS!\#3) resistor r=5.163
    Rc3 (VSS!\#3 VSS!\#2) resistor r=808.0294
    Rc6 (Y Y\#4) resistor r=5.4883
    Rd3 (Y\#4 Y\#2) resistor r=145.6659
    Rc4 (Y Y\#2) resistor r=5.6598
    Rc8 (VSS! VSS!\#2) resistor r=5.2316
    Rd4 (A\#3 A) resistor r=85.564
    Rc7 (A\#3 A\#4) resistor r=1036.0317
    MX3_M0_unmatched (Y\#3 B\#2 net1 net1) pch w=4e-06 l=1e-06 as=0 \
        ad=1e-11 ps=0 pd=1.3e-05 sa=2e-06 sb=2e-06
    MX2_M0_unmatched (net1\#2 A\#2 VDD!\#1 VDD!\#1) pch w=4e-06 l=1e-06 \
        as=0 ad=1e-11 ps=0 pd=1.3e-05 sa=2e-06 sb=2e-06
ends NOR2X1_analog_extracted
// End of subcircuit definition.

// Library name: KISTA_SOI_STDLIB2
// Cell name: OAI21X1
// View name: analog_extracted
subckt OAI21X1_analog_extracted C Y A B
    C2 (C\#4 VSS!) capacitor c=4.93911e-18
    C16 (4 VSS!) capacitor c=8.63261e-15
    C22 (Y\#1 C\#4) capacitor c=152.823a
    C24 (VDD!\#1 C\#4) capacitor c=239.793a
    C29 (C\#4 4) capacitor c=2.02875e-15
    C38 (Y\#1 VDD!\#1) capacitor c=213.703a
    C45 (Y\#1 4) capacitor c=79.0761a
    C65 (VDD!\#1 4) capacitor c=6.76366e-15
    C1 (C VSS!) capacitor c=7.93842e-18
    C28 (4 C) capacitor c=1.24866e-15
    C3 (VSS!\#1 C) capacitor c=10.5924a
    C17 (VSS!\#1 4) capacitor c=7.38795e-15
    C4 (VSS!\#1 C\#3) capacitor c=122.891a
    C30 (C\#3 4) capacitor c=1.40843e-15
    C5 (C\#2 VSS!) capacitor c=5.75829e-18
    C31 (C\#2 4) capacitor c=5.01538e-15
    C33 (C\#4 X5_5) capacitor c=503.074a
    C52 (Y\#1 X5_5) capacitor c=319.499a
    C70 (VDD!\#1 X5_5) capacitor c=480.747a
    C64 (4 VDD!) capacitor c=7.83149e-15
    C6 (Y VSS!) capacitor c=25.9356a
    C21 (Y C) capacitor c=11.1188a
    C25 (B C) capacitor c=8.54756e-18
    C12 (B VSS!) capacitor c=13.7353a
    C23 (C\#2 Y) capacitor c=15.8647a
    C26 (C\#2 B) capacitor c=15.5185a
    C27 (C\#2 B\#2) capacitor c=3.33901e-19
    C15 (B\#2 VSS!) capacitor c=11.7899a
    C39 (B Y) capacitor c=85.0175a
    C43 (B\#2 Y) capacitor c=801.951a
    C44 (4 Y) capacitor c=3.04761e-15
    C73 (4 B) capacitor c=996.835a
    C76 (B\#2 4) capacitor c=4.69001e-15
    C46 (Y\#2 4) capacitor c=1.20927e-15
    C7 (A VSS!) capacitor c=13.3675a
    C34 (A Y) capacitor c=32.1717a
    C55 (4 A) capacitor c=5.92132e-15
    C8 (A\#2 VSS!) capacitor c=6.64992e-18
    C56 (A\#2 4) capacitor c=2.03982e-15
    C9 (A\#4 VSS!) capacitor c=5.90281e-18
    C57 (A\#4 4) capacitor c=1.44727e-15
    C10 (A\#3 VSS!) capacitor c=6.58792e-19
    C37 (A\#3 Y) capacitor c=2.41024e-18
    C58 (A\#3 4) capacitor c=330.813a
    C11 (VDD!\#2 VSS!) capacitor c=14.2103a
    C54 (VDD!\#2 A\#2) capacitor c=239.793a
    C66 (VDD!\#2 4) capacitor c=191.248a
    C13 (B\#4 VSS!) capacitor c=4.3251e-18
    C40 (Y\#2 B\#4) capacitor c=416.354a
    C63 (B\#4 VDD!) capacitor c=63.5259a
    C74 (B\#4 4) capacitor c=2.57225e-15
    C14 (B\#3 VSS!) capacitor c=6.80214e-18
    C75 (B\#3 4) capacitor c=785.465a
    C80 (B\#2 net2\#4) capacitor c=13.308a
    C78 (net2\#4 B) capacitor c=37.147a
    C41 (Y\#4 B) capacitor c=53.9489a
    C35 (Y\#4 A) capacitor c=14.9778a
    C60 (net2\#3 A) capacitor c=32.8495a
    C20 (net2\#3 VSS!) capacitor c=177.02a
    C18 (net1 VSS!) capacitor c=2.98875e-18
    C42 (Y\#4 B\#3) capacitor c=104.384a
    C47 (Y\#4 4) capacitor c=1.27027e-15
    C49 (Y\#2 net1) capacitor c=96.0895a
    C50 (Y\#4 net2\#4) capacitor c=124.103a
    C61 (net2\#3 A\#4) capacitor c=183.298a
    C67 (net1 VDD!) capacitor c=76.8452a
    C77 (B\#4 net1) capacitor c=139.36a
    C79 (net2\#4 B\#3) capacitor c=164.551a
    C82 (net1 4) capacitor c=79.0526a
    C85 (net2\#3 4) capacitor c=2.49932e-15
    C36 (Y\#6 A\#4) capacitor c=91.7615a
    C48 (Y\#6 4) capacitor c=248.462a
    C51 (Y\#6 net2\#3) capacitor c=99.4671a
    C19 (VSS!\#1 net2) capacitor c=262.31a
    C32 (C\#3 net2) capacitor c=90.6145a
    C84 (net2 4) capacitor c=2.6809e-15
    C83 (net1\#2 4) capacitor c=79.4518a
    C59 (net1\#2 A\#2) capacitor c=139.36a
    C68 (net1\#2 VDD!) capacitor c=68.6314a
    C71 (X3_5 VDD!) capacitor c=30.6619a
    C62 (A\#2 X3_5) capacitor c=504.198a
    C69 (VDD!\#2 net1\#2) capacitor c=75.9625a
    C72 (VDD!\#2 X3_5) capacitor c=450.085a
    C87 (net1\#2 X3_5) capacitor c=319.404a
    C53 (Y\#2 X4_5) capacitor c=513.435a
    C81 (B\#4 X4_5) capacitor c=527.887a
    C86 (X4_5 net1) capacitor c=296.558a
    MX5_M0_unmatched (Y\#1 C\#4 VDD!\#1 VDD!\#1) pch w=4e-06 l=1e-06 as=0 \
        ad=1e-11 ps=0 pd=1.3e-05 sa=2e-06 sb=2e-06
    MX3_M0_unmatched (net1\#2 A\#2 VDD!\#2 VDD!\#2) pch w=4e-06 l=1e-06 \
        as=0 ad=1e-11 ps=0 pd=1.3e-05 sa=2e-06 sb=2e-06
    MX4_M0_unmatched (Y\#2 B\#4 net1 net1) pch w=4e-06 l=1e-06 as=0 \
        ad=1e-11 ps=0 pd=1.3e-05 sa=2e-06 sb=2e-06
    Rs1 (4 VSS!) resistor r=50
    Rc16 (VSS!\#1 VSS!) resistor r=5.3715
    Rd1 (C\#2 C\#4) resistor r=1936.0317
    Rc14 (VDD!\#1 VDD!) resistor r=2.7965
    Rd3 (C\#2 C) resistor r=85.564
    Rc9 (C\#2 C\#3) resistor r=1036.0317
    Rd9 (Y Y\#1) resistor r=3.2629
    Rc8 (Y\#1 Y\#2) resistor r=23.1127
    Rd8 (Y Y\#2) resistor r=3.199
    Rd5 (B\#2 B) resistor r=85.564
    Rd2 (A\#3 A\#4) resistor r=1036.0317
    Rc12 (A\#2 A\#3) resistor r=1936.0317
    Rc10 (A\#3 A) resistor r=85.564
    Rc15 (VDD! VDD!\#2) resistor r=2.6222
    Rd6 (B\#2 B\#4) resistor r=2536.0317
    Rc13 (B\#2 B\#3) resistor r=436.0318
    Rc7 (Y Y\#4) resistor r=5.5941
    Rd7 (Y\#4 Y\#6) resistor r=95.1
    Rc11 (Y Y\#6) resistor r=5.706
    Rc3 (net2\#4 net2\#3) resistor r=16.0189
    Rd4 (net2 net2\#3) resistor r=16.0189
    Rc1 (net2 net2\#4) resistor r=14.7418
    Rc2 (net1 net1\#2) resistor r=5.05
    MX7_M0_unmatched (Y\#4 B\#3 net2\#4 net2\#4) nch w=2e-06 l=1e-06 as=0 \
        ad=5e-12 ps=0 pd=9e-06 sa=2e-06 sb=2e-06
    MX6_M0_unmatched (Y\#6 A\#4 net2\#3 net2\#3) nch w=2e-06 l=1e-06 as=0 \
        ad=5e-12 ps=0 pd=9e-06 sa=2e-06 sb=2e-06
    MX8_M0_unmatched (net2 C\#3 VSS!\#1 VSS!\#1) nch w=2e-06 l=1e-06 as=0 \
        ad=5e-12 ps=0 pd=9e-06 sa=2e-06 sb=2e-06
ends OAI21X1_analog_extracted
// End of subcircuit definition.

// Library name: KISTA_SOI_STDLIB2
// Cell name: XNOR2X1
// View name: analog_extracted
subckt XNOR2X1_analog_extracted Y A B
    Rc14 (VDD! VDD!\#4) resistor r=2.6722
    Rc24 (VDD! VDD!\#3) resistor r=99.67m
    Rs1 (4 VSS!) resistor r=50
    Rc1 (Y Y\#1) resistor r=3.2543
    Rd5 (Y Y\#4) resistor r=5.2
    Rc20 (Y Y\#3) resistor r=3.3194
    Rd3 (Y\#1 Y\#3) resistor r=21.7879
    Rc17 (VSS! VSS!\#1) resistor r=5.5733
    Rc26 (VDD!\#1 VDD!\#3) resistor r=2.9136
    Rc25 (VDD!\#1 VDD!\#5) resistor r=238.3112
    Rc23 (VDD!\#5 VDD!\#3) resistor r=2.7357
    Rc22 (X\#7 X\#8) resistor r=1636.0317
    Rd10 (X\#8 X\#9) resistor r=1036.0317
    Rc18 (X\#8 X) resistor r=80.464
    Rc4 (net1 net1\#2) resistor r=5.05
    Rd11 (A\#2 A\#3) resistor r=2700
    Rd8 (X X\#2) resistor r=5.4795
    Rd1 (B\#2 B\#5) resistor r=2700
    Rc12 (B\#2 B\#3) resistor r=3317.6187
    Rc8 (A\#3 A\#4) resistor r=3317.6187
    Rd13 (A\#4 A\#5) resistor r=2236.0317
    Rd12 (A\#5 A) resistor r=85.564
    Rc11 (A\#5 A\#6) resistor r=436.0318
    Rc15 (X\#2 X\#3) resistor r=3.2505
    Rd2 (B\#4 B\#6) resistor r=436.0318
    Rc10 (B\#3 B\#4) resistor r=2236.0317
    Rc9 (B\#4 B) resistor r=85.564
    Rc13 (X\#2 X\#5) resistor r=3.3155
    Rc16 (X\#3 X\#5) resistor r=21.8724
    Rc5 (VDD!\#3 VDD!\#6) resistor r=2.6724
    Rd4 (VSS! VSS!\#3) resistor r=5.1972
    Rc21 (VSS! VSS!\#4) resistor r=5.4607
    Rc3 (net2 net2\#2) resistor r=10.1
    Rd6 (VSS!\#1 VSS!\#4) resistor r=217.787
    Rc2 (X\#2 X\#6) resistor r=5.1981
    Rd9 (net3 net3\#2) resistor r=15.6067
    Rd7 (net3\#2 net3\#4) resistor r=14.8611
    Rc19 (net3 net3\#4) resistor r=15.9189
    C3 (Y\#1 VDD!\#1) capacitor c=153.504a
    C8 (Y\#1 X\#7) capacitor c=298.877a
    C11 (Y\#1 4) capacitor c=1.17345e-15
    C56 (X\#7 VSS!) capacitor c=1.24862e-19
    C60 (4 VSS!) capacitor c=16.505f
    C70 (VDD!\#1 X\#7) capacitor c=195.408a
    C100 (X\#7 4) capacitor c=1.61501e-15
    C1 (VSS! Y) capacitor c=14.6027a
    C9 (4 Y) capacitor c=2.78542e-15
    C6 (X Y) capacitor c=917.75a
    C99 (4 X) capacitor c=12.722f
    C10 (Y\#4 4) capacitor c=934.738a
    C12 (Y\#3 4) capacitor c=81.4699a
    C15 (Y\#1 X7_5) capacitor c=469.646a
    C76 (VDD!\#1 X7_5) capacitor c=450.085a
    C110 (X\#7 X7_5) capacitor c=508.663a
    C2 (VSS!\#1 Y\#4) capacitor c=15.648a
    C61 (VSS!\#1 4) capacitor c=9.21443e-15
    C4 (VDD!\#3 Y\#3) capacitor c=12.6072a
    C73 (VDD!\#3 4) capacitor c=24.8239f
    C49 (VDD!\#5 VSS!) capacitor c=34.962a
    C5 (Y\#3 B\#2) capacitor c=166.054a
    C51 (B\#2 VSS!) capacitor c=18.2542a
    C68 (VDD!\#3 B\#2) capacitor c=737.871a
    C86 (B\#2 4) capacitor c=6.17013e-15
    C7 (Y\#4 X\#9) capacitor c=163.596a
    C57 (VSS!\#1 X\#9) capacitor c=16.961a
    C101 (X\#9 4) capacitor c=1.43509e-15
    C13 (Y\#3 net1) capacitor c=78.0821a
    C75 (VDD!\#3 net1) capacitor c=26.8308a
    C91 (B\#2 net1) capacitor c=162.887a
    C102 (net1 X) capacitor c=5.88844e-18
    C103 (X\#7 net1) capacitor c=1.87456e-18
    C114 (net1 4) capacitor c=78.1129a
    C16 (Y\#3 X6_5) capacitor c=327.517a
    C97 (B\#2 X6_5) capacitor c=522.273a
    C121 (X6_5 net1) capacitor c=315.608a
    C74 (VDD!\#5 net1\#2) capacitor c=109.707a
    C115 (net1\#2 4) capacitor c=78.5074a
    C14 (Y\#4 net3) capacitor c=115.645a
    C108 (X\#9 net3) capacitor c=166.396a
    C107 (net3 X) capacitor c=268.61a
    C118 (net3 4) capacitor c=1.38579e-15
    C17 (VSS! A) capacitor c=21.1746a
    C37 (4 A) capacitor c=5.44506e-15
    C18 (A\#2 VSS!) capacitor c=21.8596a
    C23 (VDD!\#5 A\#2) capacitor c=185.467a
    C38 (A\#2 4) capacitor c=3.09976e-15
    C43 (net1\#2 A\#2) capacitor c=139.36a
    C77 (VDD!\#5 X5_5) capacitor c=183.465a
    C47 (A\#2 X5_5) capacitor c=503.921a
    C122 (net1\#2 X5_5) capacitor c=315.608a
    C111 (X\#2 X5_5) capacitor c=22.0633a
    C35 (X\#2 A\#2) capacitor c=11.2995a
    C59 (X\#2 VSS!) capacitor c=56.4544a
    C104 (X\#2 net1\#2) capacitor c=22.6007a
    C92 (net1\#2 B\#3) capacitor c=1.87456e-18
    C27 (B\#3 A\#2) capacitor c=9.45114e-18
    C20 (A\#3 VSS!) capacitor c=801.328a
    C36 (X\#2 A\#3) capacitor c=631.83a
    C40 (A\#3 4) capacitor c=6.47062e-15
    C52 (B\#3 VSS!) capacitor c=13.0718a
    C69 (VDD!\#3 B\#3) capacitor c=1.49782e-15
    C83 (X\#2 B\#3) capacitor c=598.475a
    C87 (B\#3 4) capacitor c=5.1606e-15
    C80 (B\#5 X) capacitor c=587.458a
    C54 (VSS!\#1 B\#5) capacitor c=135.115a
    C88 (B\#5 4) capacitor c=3.2333e-15
    C19 (A\#6 VSS!) capacitor c=3.79121e-18
    C39 (A\#6 4) capacitor c=291.647a
    C21 (A\#4 VSS!) capacitor c=383.627a
    C41 (A\#4 4) capacitor c=5.99043e-15
    C22 (A\#5 VSS!) capacitor c=5.13707e-19
    C42 (A\#5 4) capacitor c=299.676a
    C24 (VDD!\#4 A) capacitor c=51.8544a
    C32 (X\#3 A) capacitor c=34.1002a
    C25 (VDD!\#4 A\#6) capacitor c=197.534a
    C26 (A\#5 VDD!\#4) capacitor c=3.28666e-18
    C34 (A\#5 X\#3) capacitor c=2.16135e-18
    C28 (B\#6 A\#3) capacitor c=9.63606e-18
    C30 (A\#4 B\#6) capacitor c=9.64571e-18
    C53 (B\#6 VSS!) capacitor c=16.7864a
    C89 (B\#6 4) capacitor c=844.527a
    C29 (A\#4 B) capacitor c=10.4092a
    C50 (B VSS!) capacitor c=14.3165a
    C82 (X\#2 B) capacitor c=686.963a
    C85 (4 B) capacitor c=5.13992e-15
    C31 (B\#4 A\#4) capacitor c=6.59757e-19
    C55 (B\#4 VSS!) capacitor c=3.15025e-19
    C84 (X\#2 B\#4) capacitor c=37.7219a
    C90 (B\#4 4) capacitor c=283.418a
    C93 (net2 B) capacitor c=61.2663a
    C95 (B\#4 net2) capacitor c=3.8832e-18
    C44 (A\#3 net2) capacitor c=1.12473e-18
    C64 (net2 VSS!) capacitor c=13.1228a
    C94 (B\#6 net2) capacitor c=83.616a
    C116 (net2 4) capacitor c=205.418a
    C33 (X\#5 A\#6) capacitor c=141.206a
    C72 (X\#5 VDD!\#4) capacitor c=110.552a
    C48 (A\#6 X3_5) capacitor c=504.33a
    C79 (VDD!\#4 X3_5) capacitor c=479.383a
    C113 (X\#5 X3_5) capacitor c=328.06a
    C106 (X\#5 net2\#2) capacitor c=1.13678e-18
    C45 (net2\#2 A\#4) capacitor c=110.54a
    C63 (VSS!\#3 4) capacitor c=877.911a
    C65 (VSS!\#3 net2\#2) capacitor c=58.9229a
    C62 (VSS!\#4 4) capacitor c=710.511a
    C71 (VDD!\#6 X\#3) capacitor c=136.449a
    C117 (net2\#2 4) capacitor c=248.899a
    C78 (VDD!\#6 X4_5) capacitor c=182.825a
    C98 (B\#3 X4_5) capacitor c=495.725a
    C112 (X\#3 X4_5) capacitor c=496.346a
    C46 (net3\#4 A\#3) capacitor c=98.5609a
    C67 (net3\#4 VSS!\#4) capacitor c=59.3389a
    C58 (X\#6 VSS!\#4) capacitor c=54.7765a
    C81 (X\#6 B\#6) capacitor c=101.729a
    C105 (X\#6 net2) capacitor c=46.0379a
    C109 (X\#2 net3\#4) capacitor c=11.4672a
    C120 (net3\#4 4) capacitor c=251.276a
    C119 (net3\#2 4) capacitor c=1.37054e-15
    C66 (VSS!\#1 net3\#2) capacitor c=158.406a
    C96 (net3\#2 B\#5) capacitor c=680.541a
    MX12_M0_unmatched (Y\#4 X\#9 net3 net3) nch w=2e-06 l=1e-06 as=0 \
        ad=5e-12 ps=0 pd=9e-06 sa=2e-06 sb=2e-06
    MX8_M0_unmatched (net2\#2 A\#4 VSS!\#3 VSS!\#3) nch w=2e-06 l=1e-06 \
        as=0 ad=5e-12 ps=0 pd=9e-06 sa=2e-06 sb=2e-06
    MX10_M0_unmatched (net3\#4 A\#3 VSS!\#4 VSS!\#4) nch w=2e-06 l=1e-06 \
        as=0 ad=5e-12 ps=0 pd=9e-06 sa=2e-06 sb=2e-06
    MX9_M0_unmatched (X\#6 B\#6 net2 net2) nch w=2e-06 l=1e-06 as=0 \
        ad=5e-12 ps=0 pd=9e-06 sa=2e-06 sb=2e-06
    MX11_M0_unmatched (net3\#2 B\#5 VSS!\#1 VSS!\#1) nch w=2e-06 l=1e-06 \
        as=0 ad=5e-12 ps=0 pd=9e-06 sa=2e-06 sb=2e-06
    MX7_M0_unmatched (Y\#1 X\#7 VDD!\#1 VDD!\#1) pch w=4e-06 l=1e-06 as=0 \
        ad=1e-11 ps=0 pd=1.3e-05 sa=2e-06 sb=2e-06
    MX6_M0_unmatched (Y\#3 B\#2 net1 net1) pch w=4e-06 l=1e-06 as=0 \
        ad=1e-11 ps=0 pd=1.3e-05 sa=2e-06 sb=2e-06
    MX5_M0_unmatched (net1\#2 A\#2 VDD!\#5 VDD!\#5) pch w=4e-06 l=1e-06 \
        as=0 ad=1e-11 ps=0 pd=1.3e-05 sa=2e-06 sb=2e-06
    MX3_M0_unmatched (X\#5 A\#6 VDD!\#4 VDD!\#4) pch w=4e-06 l=1e-06 as=0 \
        ad=1e-11 ps=0 pd=1.3e-05 sa=2e-06 sb=2e-06
    MX4_M0_unmatched (X\#3 B\#3 VDD!\#6 VDD!\#6) pch w=4e-06 l=1e-06 as=0 \
        ad=1e-11 ps=0 pd=1.3e-05 sa=2e-06 sb=2e-06
ends XNOR2X1_analog_extracted
// End of subcircuit definition.

// Library name: KISTA_SOI_STDLIB2
// Cell name: TIEHI
// View name: analog_extracted
subckt TIEHI_analog_extracted Y
    Rc2 (Y Y\#1) resistor r=2.675
    Rc4 (VDD!\#1 VDD!) resistor r=2.6184
    Rd1 (net1\#3 net1\#4) resistor r=3136.0317
    Rs1 (1 VSS!) resistor r=50
    Rc3 (VSS!\#1 VSS!) resistor r=5.1382
    Rd3 (net1\#4 net1\#5) resistor r=436.0318
    Rd2 (net1\#4 net1) resistor r=80.464
    Rc1 (net1 net1\#2) resistor r=10.1
    MX1_M0_unmatched (net1\#2 net1\#5 VSS!\#1 VSS!\#1) nch w=2e-06 l=1e-06 \
        as=0 ad=5e-12 ps=0 pd=9e-06 sa=2e-06 sb=2e-06
    C2 (VDD!\#1 Y\#1) capacitor c=139.132a
    C5 (Y\#1 net1\#3) capacitor c=347.031a
    C16 (VDD!\#1 net1\#3) capacitor c=222.456a
    C4 (Y\#1 1) capacitor c=401.69a
    C15 (VDD!\#1 1) capacitor c=182.471a
    C20 (net1\#3 1) capacitor c=3.33588e-15
    C3 (1 Y) capacitor c=985.123a
    C1 (VSS! Y) capacitor c=1.83287e-18
    C6 (Y\#1 X0_5) capacitor c=408.586a
    C7 (VDD!\#1 VSS!) capacitor c=1.93478e-18
    C8 (1 VSS!) capacitor c=2.95855e-15
    C18 (VDD!\#1 X0_5) capacitor c=408.586a
    C14 (1 VDD!) capacitor c=5.51052e-15
    C17 (X0_5 VDD!) capacitor c=12.2034a
    C23 (net1\#3 X0_5) capacitor c=507.931a
    C9 (VSS!\#1 1) capacitor c=2.92465e-15
    C10 (net1 VSS!) capacitor c=3.78421e-18
    C12 (net1\#2 VSS!) capacitor c=58.7187a
    C13 (net1\#2 VSS!\#1) capacitor c=44.4275a
    C19 (net1 1) capacitor c=6.2293e-15
    C22 (net1\#2 1) capacitor c=356.758a
    C21 (net1\#5 1) capacitor c=758.472a
    C11 (VSS!\#1 net1\#5) capacitor c=185.868a
    MX0_M0_unmatched (Y\#1 net1\#3 VDD!\#1 VDD!\#1) pch w=4e-06 l=1e-06 \
        as=0 ad=1e-11 ps=0 pd=1.3e-05 sa=2e-06 sb=2e-06
ends TIEHI_analog_extracted
// End of subcircuit definition.

// Library name: KISTA_SOI_STDLIB2
// Cell name: TIELO
// View name: analog_extracted
subckt TIELO_analog_extracted Y
    Rc2 (Y Y\#1) resistor r=5.1
    Rs1 (1 VSS!) resistor r=50
    Rc1 (net1\#4 net1\#5) resistor r=2836.0317
    Rc4 (VSS!\#1 VSS!) resistor r=5.0934
    Rc3 (VDD!\#1 VDD!) resistor r=2.6632
    Rd1 (net1\#3 net1\#4) resistor r=736.0318
    Rd3 (net1\#4 net1) resistor r=88.139
    C2 (1 Y) capacitor c=734.017a
    C15 (VDD!\#1 net1) capacitor c=78.277a
    C16 (VDD!\#1 net1\#3) capacitor c=239.843a
    C5 (VDD!\#1 VSS!) capacitor c=1.44171e-18
    C1 (Y\#1 VSS!) capacitor c=104.557a
    C3 (Y\#1 1) capacitor c=474.882a
    C6 (1 VSS!) capacitor c=5.52946e-15
    C13 (VDD!\#1 1) capacitor c=2.60933e-15
    C18 (net1 1) capacitor c=6.15263e-15
    C19 (net1\#3 1) capacitor c=587.485a
    C4 (Y\#1 net1\#5) capacitor c=223.647a
    C7 (VSS!\#1 1) capacitor c=491.717a
    C8 (net1\#5 VSS!) capacitor c=206.519a
    C9 (VSS!\#1 net1) capacitor c=2.2465e-18
    C20 (net1\#5 1) capacitor c=3.58471e-15
    C10 (net1\#4 VSS!\#1) capacitor c=2.14281e-19
    C11 (X1_4 VSS!) capacitor c=3.06619e-20
    C17 (VDD!\#1 X1_4) capacitor c=414.626a
    C12 (1 VDD!) capacitor c=2.94157e-15
    C14 (net1 VDD!) capacitor c=60.8552a
    C21 (net1\#4 1) capacitor c=559.84a
    C22 (X1_4 net1) capacitor c=408.586a
    C23 (net1\#3 X1_4) capacitor c=507.931a
    MX0_M0_unmatched (Y\#1 net1\#5 VSS!\#1 VSS!\#1) nch w=2e-06 l=1e-06 \
        as=0 ad=5e-12 ps=0 pd=9e-06 sa=2e-06 sb=2e-06
    MX1_M0_unmatched (net1 net1\#3 VDD!\#1 VDD!\#1) pch w=4e-06 l=1e-06 \
        as=0 ad=1e-11 ps=0 pd=1.3e-05 sa=2e-06 sb=2e-06
ends TIELO_analog_extracted
// End of subcircuit definition.

// Library name: KISTA_SOI_STDLIB2
// Cell name: BUFX3
// View name: analog_extracted
subckt BUFX3_analog_extracted Y A
    C1 (VDD!\#1 Y\#2) capacitor c=275.887a
    C9 (Y\#2 YN\#5) capacitor c=473.193a
    C13 (YN\#4 Y\#2) capacitor c=13.6817a
    C15 (Y\#2 3) capacitor c=866.048a
    C23 (VDD!\#1 YN\#5) capacitor c=453.686a
    C25 (YN\#4 VDD!\#1) capacitor c=193.098a
    C28 (VDD!\#1 3) capacitor c=5.751e-15
    C58 (YN\#5 3) capacitor c=1.25263e-15
    C60 (YN\#4 3) capacitor c=4.52954e-15
    C2 (Y\#2 A) capacitor c=4.42969e-18
    C37 (YN\#4 A) capacitor c=517.981a
    C41 (3 A) capacitor c=6.16994e-15
    C4 (A\#3 Y\#2) capacitor c=2.80764e-19
    C40 (A\#3 YN\#4) capacitor c=30.1501a
    C44 (A\#3 3) capacitor c=345.011a
    C8 (Y\#2 YN) capacitor c=16.9501a
    C22 (VDD!\#1 YN) capacitor c=10.8634a
    C57 (3 YN) capacitor c=3.76073e-15
    C7 (YN Y) capacitor c=234.23a
    C12 (YN\#4 Y) capacitor c=9.72944e-18
    C14 (3 Y) capacitor c=1.36087e-15
    C17 (Y\#2 X4_5) capacitor c=803.197a
    C30 (VDD!\#1 X4_5) capacitor c=218.499a
    C62 (YN\#5 X4_5) capacitor c=508.137a
    C5 (VSS! Y) capacitor c=3.57024e-18
    C10 (Y\#1 YN) capacitor c=16.9161a
    C16 (Y\#1 3) capacitor c=669.667a
    C21 (VDD!\#1 VSS!) capacitor c=13.8063a
    C24 (YN\#4 VDD!) capacitor c=50.3617a
    C27 (3 VDD!) capacitor c=4.46154e-15
    C33 (VSS! A) capacitor c=18.4435a
    C18 (VDD!\#2 A) capacitor c=21.508a
    C20 (A\#3 VDD!\#2) capacitor c=1.36323e-18
    C26 (VDD!\#2 YN\#4) capacitor c=78.277a
    C29 (VDD!\#2 3) capacitor c=46.4299a
    C36 (A\#3 VSS!) capacitor c=4.89749e-19
    C46 (YN\#5 VSS!) capacitor c=3.89109e-18
    C49 (YN\#4 VSS!) capacitor c=13.0145a
    C54 (3 VSS!) capacitor c=4.49794e-15
    C11 (Y\#1 YN\#7) capacitor c=209.465a
    C59 (YN\#7 3) capacitor c=758.774a
    C31 (X2_5 VDD!) capacitor c=30.6619a
    C32 (VDD!\#2 X2_5) capacitor c=406.72a
    C63 (YN\#4 X2_5) capacitor c=175.629a
    C45 (A\#2 X2_5) capacitor c=531.582a
    C19 (VDD!\#2 A\#2) capacitor c=238.688a
    C34 (A\#2 VSS!) capacitor c=8.53277e-18
    C38 (YN\#4 A\#2) capacitor c=189.421a
    C42 (A\#2 3) capacitor c=599.791a
    C3 (Y\#1 A\#4) capacitor c=2.43738e-18
    C39 (YN\#4 A\#4) capacitor c=349.37a
    C43 (A\#4 3) capacitor c=3.4287e-15
    C6 (VSS!\#1 Y\#1) capacitor c=178.899a
    C48 (VSS!\#1 YN\#7) capacitor c=294.12a
    C47 (VSS!\#1 YN) capacitor c=62.8002a
    C50 (YN\#4 VSS!\#1) capacitor c=22.8038a
    C51 (YN\#3 VSS!) capacitor c=50.3617a
    C52 (YN\#3 VSS!\#1) capacitor c=78.2915a
    C55 (VSS!\#1 3) capacitor c=5.86818e-15
    C35 (VSS!\#2 A\#4) capacitor c=192.573a
    C53 (VSS!\#2 YN\#3) capacitor c=44.4275a
    C56 (VSS!\#2 3) capacitor c=353.883a
    C61 (YN\#3 3) capacitor c=661.552a
    MX3_M0_unmatched (Y\#1 YN\#7 VSS!\#1 VSS!\#1) nch w=6e-06 l=1e-06 as=0 \
        ad=1.5e-11 ps=0 pd=1.7e-05 sa=2e-06 sb=2e-06
    MX5_M0_unmatched (YN\#3 A\#4 VSS!\#2 VSS!\#2) nch w=2e-06 l=1e-06 as=0 \
        ad=5e-12 ps=0 pd=9e-06 sa=2e-06 sb=2e-06
    Rd3 (A\#3 A) resistor r=85.564
    Rc4 (YN YN\#4) resistor r=10.9579
    Rc6 (Y Y\#2) resistor r=1.2083
    Rc5 (Y Y\#1) resistor r=1.8167
    Rc7 (VDD!\#1 VDD!) resistor r=1.1298
    Rd4 (YN\#5 YN\#6) resistor r=1336.0317
    Rd6 (YN\#6 YN) resistor r=80.464
    Rc2 (YN\#6 YN\#7) resistor r=436.0318
    Rc8 (VDD! VDD!\#2) resistor r=2.6222
    Rd1 (A\#2 A\#3) resistor r=736.0318
    Rc1 (A\#3 A\#4) resistor r=2836.0317
    Rs1 (3 VSS!) resistor r=50
    Rd5 (YN YN\#3) resistor r=19.1586
    Rc3 (YN\#4 YN\#3) resistor r=11.2136
    Rc9 (VSS!\#1 VSS!) resistor r=1.8882
    Rc10 (VSS! VSS!\#2) resistor r=5.0972
    MX4_M0_unmatched (Y\#2 YN\#5 VDD!\#1 VDD!\#1) pch w=1.2e-05 l=1e-06 \
        as=0 ad=3e-11 ps=0 pd=2.9e-05 sa=2e-06 sb=2e-06
    MX2_M0_unmatched (YN\#4 A\#2 VDD!\#2 VDD!\#2) pch w=4e-06 l=1e-06 as=0 \
        ad=1e-11 ps=0 pd=1.3e-05 sa=2e-06 sb=2e-06
ends BUFX3_analog_extracted
// End of subcircuit definition.

// Library name: KISTA_SOI_STDLIB2
// Cell name: BUFX4
// View name: analog_extracted
subckt BUFX4_analog_extracted A Y
    C23 (VDD!\#4 Y\#2) capacitor c=342.314a
    C26 (VDD!\#4 YN\#2310) capacitor c=350.54a
    C30 (VDD!\#4 3) capacitor c=101.725a
    C51 (Y\#2 YN\#2310) capacitor c=345.113a
    C59 (Y\#2 3) capacitor c=1.1017e-15
    C64 (YN\#2310 3) capacitor c=1.28981e-15
    C1 (VDD!\#4 VSS!) capacitor c=20.4102a
    C10 (YN\#2310 VSS!) capacitor c=2.80851e-18
    C16 (3 VSS!) capacitor c=9.03776e-15
    C2 (A VSS!) capacitor c=7.05456e-18
    C43 (3 A) capacitor c=5.32221e-15
    C3 (A\#2 VSS!) capacitor c=8.57801e-18
    C37 (Y\#2 A\#2) capacitor c=4.4656e-18
    C44 (A\#2 3) capacitor c=1.26397e-15
    C4 (VSS!\#3 A) capacitor c=19.3507a
    C19 (VSS!\#3 3) capacitor c=452.397a
    C5 (VSS!\#3 A\#4) capacitor c=248.614a
    C45 (A\#4 3) capacitor c=1.79654e-15
    C6 (A\#3 VSS!) capacitor c=3.74868e-19
    C46 (A\#3 3) capacitor c=292.05a
    C7 (Y VSS!) capacitor c=7.7099e-18
    C36 (Y A) capacitor c=2.94585e-18
    C38 (A\#3 Y) capacitor c=1.86715e-19
    C58 (3 Y) capacitor c=1.27525e-15
    C9 (YN\#5 VSS!) capacitor c=5.96116e-18
    C50 (Y\#2 YN\#5) capacitor c=345.145a
    C63 (YN\#5 3) capacitor c=1.20843e-15
    C14 (VSS!\#3 YN\#3) capacitor c=183.784a
    C41 (YN\#3 A\#4) capacitor c=258.63a
    C68 (YN\#3 3) capacitor c=906.515a
    C15 (YN\#6 VSS!) capacitor c=5.54022e-20
    C57 (YN\#6 Y) capacitor c=721.528a
    C69 (YN\#6 3) capacitor c=3.94195e-15
    C17 (VSS!\#1 3) capacitor c=3.83152e-15
    C18 (VSS!\#4 3) capacitor c=251.01a
    C8 (Y\#1 VSS!\#1) capacitor c=209.535a
    C56 (YN\#3 Y\#1) capacitor c=7.60198e-18
    C60 (Y\#1 3) capacitor c=483.224a
    C11 (VSS!\#1 YN\#8) capacitor c=242.197a
    C52 (Y\#1 YN\#8) capacitor c=243.524a
    C65 (YN\#8 3) capacitor c=1.58831e-15
    C71 (YN\#2310 6) capacitor c=522.683a
    C33 (VDD!\#4 6) capacitor c=149.256a
    C61 (Y\#2 6) capacitor c=154.663a
    C70 (YN\#5 6) capacitor c=481.522a
    C32 (VDD!\#1 6) capacitor c=610.39a
    C24 (VDD!\#1 YN\#5) capacitor c=345.416a
    C29 (VDD!\#1 3) capacitor c=3.41435e-15
    C28 (3 VDD!) capacitor c=8.99794e-15
    C25 (VDD!\#4 YN) capacitor c=9.4262e-18
    C12 (VSS!\#4 YN) capacitor c=13.1103a
    C48 (YN Y) capacitor c=657.277a
    C54 (YN\#4 Y) capacitor c=14.29a
    C39 (YN\#4 A) capacitor c=397.983a
    C20 (VDD!\#3 A) capacitor c=8.40444e-18
    C21 (VDD!\#3 A\#2) capacitor c=346.707a
    C22 (A\#3 VDD!\#3) capacitor c=5.32693e-19
    C42 (A\#3 YN\#4) capacitor c=22.5449a
    C27 (VDD!\#3 YN\#4) capacitor c=287.341a
    C31 (VDD!\#3 3) capacitor c=111.034a
    C40 (YN\#4 A\#2) capacitor c=366.015a
    C49 (Y\#2 YN) capacitor c=80.6784a
    C55 (YN\#4 Y\#2) capacitor c=19.7646a
    C62 (3 YN) capacitor c=5.72519e-15
    C67 (YN\#4 3) capacitor c=2.87602e-15
    C66 (YN\#9 3) capacitor c=1.79894e-15
    C13 (VSS!\#4 YN\#9) capacitor c=243.696a
    C53 (Y\#1 YN\#9) capacitor c=243.491a
    C34 (8 VDD!) capacitor c=30.6619a
    C35 (VDD!\#3 8) capacitor c=604.977a
    C47 (A\#2 8) capacitor c=531.582a
    C72 (YN\#4 8) capacitor c=181.312a
    MX4_M0_unmatched (Y\#2 YN\#2310 VDD!\#4 VDD!\#4) pch w=8e-06 l=1e-06 \
        as=2.4e-11 ad=0 ps=2.2e-05 pd=0 sa=2e-06 sb=2e-06
    MM1 (Y\#2 YN\#5 VDD!\#1 VDD!\#1) pch w=8e-06 l=1e-06 as=0 ad=2.4e-11 \
        ps=0 pd=2.2e-05 sa=2e-06 sb=2e-06
    MM0 (YN\#4 A\#2 VDD!\#3 VDD!\#3) pch w=8e-06 l=1e-06 as=0 ad=2e-11 \
        ps=0 pd=2.1e-05 sa=2e-06 sb=2e-06
    Rs1 (3 VSS!) resistor r=50
    Rc12 (VSS! VSS!\#3) resistor r=2.6222
    Rc8 (A\#2 A\#3) resistor r=1336.0317
    Rc7 (A\#3 A\#4) resistor r=1336.0317
    Rc10 (A\#3 A) resistor r=85.564
    Rc6 (Y Y\#2) resistor r=1.675
    Rd4 (YN\#5 YN\#6) resistor r=1336.0317
    Rd5 (VSS! VSS!\#1) resistor r=2.8307
    Rd1 (VSS! VSS!\#4) resistor r=2.7532
    Rc11 (VSS!\#1 VSS!\#4) resistor r=111.9025
    Rc5 (Y Y\#1) resistor r=2.675
    Rc2 (YN\#6 YN\#8) resistor r=1336.0317
    Rd7 (YN\#6 YN\#7) resistor r=258.7097
    Rc4 (YN\#7 YN\#2310) resistor r=1327.5659
    Rc9 (VDD!\#1 VDD!\#4) resistor r=34.9995
    Rd3 (VDD! VDD!\#1) resistor r=1.6323
    Rd2 (VDD! VDD!\#4) resistor r=1.5518
    Rd9 (YN\#7 YN\#9) resistor r=1327.5659
    Rc3 (YN\#7 YN) resistor r=114.0987
    Rd8 (YN YN\#4) resistor r=9.5341
    Rc13 (YN YN\#3) resistor r=16.807
    Rd6 (YN\#4 YN\#3) resistor r=5.205
    Rc14 (VDD! VDD!\#3) resistor r=1.4222
    MM2 (YN\#3 A\#4 VSS!\#3 VSS!\#3) nch w=4e-06 l=1e-06 as=0 ad=1e-11 \
        ps=0 pd=1.3e-05 sa=2e-06 sb=2e-06
    MM3 (Y\#1 YN\#8 VSS!\#1 VSS!\#1) nch w=4e-06 l=1e-06 as=0 ad=1.2e-11 \
        ps=0 pd=1.4e-05 sa=2e-06 sb=2e-06
    MX7_M0_unmatched (Y\#1 YN\#9 VSS!\#4 VSS!\#4) nch w=4e-06 l=1e-06 \
        as=1.2e-11 ad=0 ps=1.4e-05 pd=0 sa=2e-06 sb=2e-06
ends BUFX4_analog_extracted
// End of subcircuit definition.

// Library name: KISTA_SOI_STDLIB2
// Cell name: BUFX8
// View name: analog_extracted
subckt BUFX8_analog_extracted A Y
    C31 (Y\#1 VDD!\#1) capacitor c=196.338a
    C33 (VDD!\#1 YN\#5) capacitor c=351.377a
    C59 (Y\#1 YN\#5) capacitor c=411.92a
    C73 (Y\#1 3) capacitor c=618.039a
    C79 (YN\#5 3) capacitor c=1.85673e-15
    C87 (YN\#4 3) capacitor c=3.27977e-15
    C12 (YN\#5 VSS!) capacitor c=1.10427e-18
    C1 (VDD!\#7 VSS!) capacitor c=46.4306a
    C2 (A\#2 VSS!) capacitor c=17.1051a
    C43 (YN\#4 A\#2) capacitor c=348.774a
    C50 (A\#2 3) capacitor c=1.26755e-15
    C3 (A\#7 VSS!) capacitor c=6.49541e-18
    C44 (YN\#4 A\#7) capacitor c=346.646a
    C51 (A\#7 3) capacitor c=1.2385e-15
    C7 (A\#3 VSS!) capacitor c=2.6427e-20
    C47 (A\#3 YN\#4) capacitor c=1.16886e-15
    C54 (A\#3 3) capacitor c=3.97655e-15
    C8 (A\#4 VSS!) capacitor c=1.16803e-19
    C48 (A\#4 YN\#4) capacitor c=34.0408a
    C55 (A\#4 3) capacitor c=239.728a
    C9 (Y VSS!) capacitor c=38.5175a
    C41 (A\#3 Y) capacitor c=7.59808e-18
    C52 (A\#5 3) capacitor c=1.68492e-15
    C67 (YN\#4 Y) capacitor c=5.80398e-18
    C72 (3 Y) capacitor c=3.62848e-15
    C4 (VSS!\#8 A\#5) capacitor c=245.746a
    C21 (VSS!\#8 YN\#4) capacitor c=20.0976a
    C13 (YN\#2312 VSS!) capacitor c=5.85336e-19
    C60 (Y\#1 YN\#2312) capacitor c=420.597a
    C80 (YN\#2312 3) capacitor c=1.97868e-15
    C14 (YN\#2314 VSS!) capacitor c=6.35813e-18
    C81 (YN\#2314 3) capacitor c=1.93175e-15
    C15 (YN\#2316 VSS!) capacitor c=1.2262e-18
    C36 (VDD!\#7 YN\#2316) capacitor c=355.516a
    C82 (YN\#2316 3) capacitor c=2.00159e-15
    C23 (YN\#6 VSS!) capacitor c=2.4692e-18
    C69 (YN\#6 Y) capacitor c=725.729a
    C89 (YN\#6 3) capacitor c=3.95431e-15
    C92 (YN\#5 6) capacitor c=481.565a
    C39 (VDD!\#1 6) capacitor c=992.654a
    C93 (YN\#2312 6) capacitor c=510.854a
    C94 (YN\#2314 6) capacitor c=510.919a
    C95 (YN\#2316 6) capacitor c=524.746a
    C77 (Y\#5 6) capacitor c=327.123a
    C63 (Y\#5 YN\#2314) capacitor c=421.648a
    C64 (Y\#5 YN\#2316) capacitor c=415.266a
    C68 (YN\#4 Y\#5) capacitor c=3.44739e-18
    C75 (Y\#5 3) capacitor c=689.827a
    C38 (VDD!\#4 3) capacitor c=19.5703f
    C32 (Y\#5 VDD!\#6) capacitor c=491.228a
    C34 (VDD!\#6 YN\#2312) capacitor c=332.879a
    C35 (VDD!\#6 YN\#2314) capacitor c=326.539a
    C70 (YN\#7 Y) capacitor c=1.28128e-15
    C71 (YN\#8 Y) capacitor c=1.23418e-15
    C74 (Y\#4 3) capacitor c=764.71a
    C90 (YN\#7 3) capacitor c=4.54319e-15
    C91 (YN\#8 3) capacitor c=4.45643e-15
    C61 (Y\#4 YN\#2310) capacitor c=178.958a
    C83 (YN\#2310 3) capacitor c=1.00015e-15
    C10 (Y\#4 VSS!\#1) capacitor c=132.417a
    C16 (VSS!\#1 YN\#2310) capacitor c=243.302a
    C24 (YN\#7 VSS!\#6) capacitor c=8.57901e-18
    C17 (VSS!\#6 YN\#2311) capacitor c=230.011a
    C25 (YN\#8 VSS!\#6) capacitor c=8.58473e-18
    C18 (VSS!\#6 YN\#2313) capacitor c=229.546a
    C62 (Y\#4 YN\#2311) capacitor c=183.115a
    C84 (YN\#2311 3) capacitor c=1.06783e-15
    C85 (YN\#2313 3) capacitor c=1.06169e-15
    C11 (Y\#3 VSS!\#6) capacitor c=291.948a
    C65 (Y\#3 YN\#2313) capacitor c=183.455a
    C76 (Y\#3 3) capacitor c=837.724a
    C58 (YN Y) capacitor c=726.514a
    C78 (3 YN) capacitor c=6.0262e-15
    C66 (Y\#3 YN\#2315) capacitor c=180.052a
    C19 (VSS!\#7 YN) capacitor c=50.0591a
    C20 (VSS!\#7 YN\#2315) capacitor c=245.866a
    C86 (YN\#2315 3) capacitor c=1.10811e-15
    C45 (YN\#3 A\#5) capacitor c=255.627a
    C26 (VSS!\#4 3) capacitor c=20.6779f
    C88 (YN\#3 3) capacitor c=492.56a
    C22 (VSS!\#5 YN\#3) capacitor c=211.578a
    C5 (VSS!\#5 A) capacitor c=21.9638a
    C42 (YN\#4 A) capacitor c=819.184a
    C49 (3 A) capacitor c=6.05781e-15
    C53 (A\#6 3) capacitor c=1.73794e-15
    C6 (VSS!\#5 A\#6) capacitor c=242.675a
    C46 (YN\#3 A\#6) capacitor c=245.025a
    C28 (VDD!\#5 A) capacitor c=8.55475e-18
    C30 (A\#4 VDD!\#5) capacitor c=3.82381e-19
    C29 (VDD!\#5 A\#7) capacitor c=345.416a
    C37 (VDD!\#5 YN\#4) capacitor c=345.252a
    C57 (A\#7 8) capacitor c=509.903a
    C40 (VDD!\#5 8) capacitor c=773.124a
    C27 (VDD!\#8 A\#2) capacitor c=343.735a
    C56 (A\#2 8) capacitor c=496.246a
    C96 (YN\#4 8) capacitor c=199.89a
    MX12_M0_unmatched (Y\#1 YN\#5 VDD!\#1 VDD!\#1) pch w=8e-06 l=1e-06 \
        as=0 ad=2.4e-11 ps=0 pd=2.2e-05 sa=2e-06 sb=2e-06
    MX7_M0_unmatched (Y\#5 YN\#2316 VDD!\#7 VDD!\#7) pch w=8e-06 l=1e-06 \
        as=2.4e-11 ad=0 ps=2.2e-05 pd=0 sa=2e-06 sb=2e-06
    MX10_M0_unmatched (Y\#5 YN\#2314 VDD!\#6 VDD!\#6) pch w=8e-06 l=1e-06 \
        as=0 ad=2.4e-11 ps=0 pd=2.2e-05 sa=2e-06 sb=2e-06
    MX11_M0_unmatched (Y\#1 YN\#2312 VDD!\#6 VDD!\#6) pch w=8e-06 l=1e-06 \
        as=0 ad=2.4e-11 ps=0 pd=2.2e-05 sa=2e-06 sb=2e-06
    MX8_M0_unmatched (YN\#4 A\#7 VDD!\#5 VDD!\#5) pch w=8e-06 l=1e-06 as=0 \
        ad=2.4e-11 ps=0 pd=2.2e-05 sa=2e-06 sb=2e-06
    MX9_M0_unmatched (YN\#4 A\#2 VDD!\#8 VDD!\#8) pch w=8e-06 l=1e-06 as=0 \
        ad=2.4e-11 ps=0 pd=2.2e-05 sa=2e-06 sb=2e-06
    Rd2 (VDD! VDD!\#5) resistor r=1.4222
    Rc9 (VDD! VDD!\#4) resistor r=66.34m
    Rs1 (3 VSS!) resistor r=50
    Rc19 (A\#2 A\#3) resistor r=1336.0317
    Rd17 (A\#4 A\#7) resistor r=1327.5659
    Rc21 (A\#3 A\#4) resistor r=258.7097
    Rd18 (A\#3 A\#5) resistor r=1336.0317
    Rc14 (Y Y\#1) resistor r=1.8545
    Rd7 (YN\#5 YN\#6) resistor r=1936.0317
    Rc17 (VDD!\#1 VDD!\#2) resistor r=1.4962
    Rc20 (Y Y\#5) resistor r=1.575
    Rc1 (VDD!\#2 VDD!\#7) resistor r=4.3619
    Rc18 (YN\#9 YN\#2316) resistor r=1927.5659
    Rc6 (VDD!\#7 VDD!\#4) resistor r=2.1591
    Rc7 (VDD!\#2 VDD!\#4) resistor r=100.2m
    Rc12 (VDD!\#2 VDD!\#6) resistor r=1.4224
    Rd13 (YN\#8 YN\#2314) resistor r=1927.5659
    Rd1 (Y\#1 Y\#4) resistor r=28.6426
    Rc4 (YN\#7 YN\#2312) resistor r=1927.5659
    Rd12 (YN\#6 YN\#7) resistor r=258.7097
    Rc2 (YN\#6 YN\#2310) resistor r=736.0318
    Rd8 (YN\#8 YN\#9) resistor r=292.3445
    Rc3 (YN\#7 YN\#8) resistor r=292.3445
    Rc10 (Y Y\#4) resistor r=3.2691
    Rc15 (VSS!\#1 VSS!\#2) resistor r=2.6962
    Rd14 (YN\#7 YN\#2311) resistor r=727.5659
    Rc22 (YN\#8 YN\#2313) resistor r=727.5659
    Rd6 (VSS!\#2 VSS!\#6) resistor r=2.6224
    Rd10 (Y Y\#3) resistor r=2.775
    Rd15 (YN YN\#4) resistor r=10.0945
    Rc23 (YN\#9 YN) resistor r=114.0987
    Rd16 (YN\#9 YN\#2315) resistor r=727.5659
    Rc24 (YN YN\#3) resistor r=16.128
    Rc13 (VSS!\#4 VSS!\#8) resistor r=2.6224
    Rd9 (YN\#4 YN\#3) resistor r=5.2096
    Rd5 (VSS! VSS!\#4) resistor r=66.34m
    Rd4 (VSS! VSS!\#5) resistor r=2.6222
    Rd3 (VSS!\#7 VSS!\#4) resistor r=3.9531
    Rc16 (VSS!\#2 VSS!\#7) resistor r=7.9861
    Rc11 (VSS!\#2 VSS!\#4) resistor r=99.5m
    Rc25 (A\#4 A\#6) resistor r=1327.5659
    Rd11 (A\#4 A) resistor r=119.1987
    Rc5 (VDD!\#4 VDD!\#8) resistor r=1.4224
    MX6_M0_unmatched (Y\#4 YN\#2310 VSS!\#1 VSS!\#1) nch w=4e-06 l=1e-06 \
        as=1.2e-11 ad=0 ps=1.4e-05 pd=0 sa=2e-06 sb=2e-06
    MX5_M0_unmatched (Y\#4 YN\#2311 VSS!\#6 VSS!\#6) nch w=4e-06 l=1e-06 \
        as=1.2e-11 ad=0 ps=1.4e-05 pd=0 sa=2e-06 sb=2e-06
    MX4_M0_unmatched (Y\#3 YN\#2313 VSS!\#6 VSS!\#6) nch w=4e-06 l=1e-06 \
        as=1.2e-11 ad=0 ps=1.4e-05 pd=0 sa=2e-06 sb=2e-06
    MX13_M0_unmatched (Y\#3 YN\#2315 VSS!\#7 VSS!\#7) nch w=4e-06 l=1e-06 \
        as=1.2e-11 ad=0 ps=1.4e-05 pd=0 sa=2e-06 sb=2e-06
    MX3_M0_unmatched (YN\#3 A\#5 VSS!\#8 VSS!\#8) nch w=4e-06 l=1e-06 \
        as=1.2e-11 ad=0 ps=1.4e-05 pd=0 sa=2e-06 sb=2e-06
    MX2_M0_unmatched (YN\#3 A\#6 VSS!\#5 VSS!\#5) nch w=4e-06 l=1e-06 \
        as=1.2e-11 ad=0 ps=1.4e-05 pd=0 sa=2e-06 sb=2e-06
ends BUFX8_analog_extracted
// End of subcircuit definition.

// Library name: KISTA_SOI_STDLIB2
// Cell name: BUFX9
// View name: analog_extracted
subckt BUFX9_analog_extracted A Y
    Rs1 (3 VSS!) resistor r=50
    Rc16 (VSS! VSS!\#3) resistor r=1.8139
    Rc11 (A\#2 A\#3) resistor r=1336.0317
    Rc10 (A\#3 A\#4) resistor r=436.0318
    Rc13 (A\#3 A) resistor r=85.564
    Rc14 (VDD! VDD!\#3) resistor r=1.0556
    Rc12 (VDD! VDD!\#4) resistor r=1.1841
    Rd11 (Y Y\#5) resistor r=1.1083
    Rc6 (YN\#4 YN\#3) resistor r=3.4522
    Rc7 (YN YN\#4) resistor r=9.6628
    Rd12 (YN YN\#3) resistor r=14.5352
    Rc5 (Y Y\#3) resistor r=1.9167
    Rd1 (VSS! VSS!\#1) resistor r=2.0232
    Rd3 (VSS! VSS!\#4) resistor r=1.9441
    Rd5 (YN\#8 YN) resistor r=114.0987
    Rd9 (YN\#8 YN\#2313) resistor r=1327.5659
    Rd2 (VDD! VDD!\#1) resistor r=1.2668
    Rc17 (VDD!\#1 VDD!\#4) resistor r=20.1609
    Rc4 (YN\#7 YN\#2311) resistor r=1327.5659
    Rd4 (YN\#5 YN\#6) resistor r=1336.0317
    Rd8 (YN\#6 YN\#7) resistor r=258.7097
    Rc2 (YN\#6 YN\#9) resistor r=436.0318
    Rd7 (Y Y\#1) resistor r=1.3897
    Rd6 (Y Y\#4) resistor r=2.405
    Rc8 (Y\#1 Y\#4) resistor r=14.8205
    Rc3 (YN\#7 YN\#8) resistor r=292.3445
    Rd10 (YN\#7 YN\#2310) resistor r=427.5659
    Rc9 (YN\#8 YN\#2312) resistor r=427.5659
    Rc15 (VSS!\#1 VSS!\#4) resistor r=55.3272
    MM2 (YN\#3 A\#4 VSS!\#3 VSS!\#3) nch w=6e-06 l=1e-06 as=0 ad=1.5e-11 \
        ps=0 pd=1.7e-05 sa=2e-06 sb=2e-06
    MM3 (Y\#4 YN\#9 VSS!\#1 VSS!\#1) nch w=6e-06 l=1e-06 as=0 ad=1.5e-11 \
        ps=0 pd=1.7e-05 sa=2e-06 sb=2e-06
    MX5_M0_unmatched (Y\#3 YN\#2312 VSS!\#4 VSS!\#4) nch w=6e-06 l=1e-06 \
        as=1.8e-11 ad=0 ps=1.8e-05 pd=0 sa=2e-06 sb=2e-06
    MM4 (Y\#3 YN\#2310 VSS!\#1 VSS!\#1) nch w=6e-06 l=1e-06 as=0 \
        ad=1.8e-11 ps=0 pd=1.8e-05 sa=2e-06 sb=2e-06
    C27 (VDD!\#4 Y\#5) capacitor c=477.712a
    C31 (VDD!\#4 YN\#2313) capacitor c=458.82a
    C35 (VDD!\#4 3) capacitor c=101.725a
    C56 (Y\#5 YN\#2313) capacitor c=444.396a
    C67 (Y\#5 3) capacitor c=227.6a
    C74 (YN\#2313 3) capacitor c=1.28983e-15
    C1 (VDD!\#4 VSS!) capacitor c=16.6221a
    C11 (YN\#2313 VSS!) capacitor c=5.6901e-18
    C20 (3 VSS!) capacitor c=9.03131e-15
    C2 (A VSS!) capacitor c=9.28312e-18
    C47 (3 A) capacitor c=4.22697e-15
    C3 (A\#2 VSS!) capacitor c=1.40653e-18
    C42 (Y\#5 A\#2) capacitor c=3.94577e-18
    C48 (A\#2 3) capacitor c=1.26397e-15
    C4 (VSS!\#3 A) capacitor c=51.8544a
    C23 (VSS!\#3 3) capacitor c=552.522a
    C5 (VSS!\#3 A\#4) capacitor c=302.184a
    C49 (A\#4 3) capacitor c=800.282a
    C6 (A\#3 VSS!\#3) capacitor c=3.78432e-18
    C50 (A\#3 3) capacitor c=224.19a
    C46 (A\#3 YN\#4) capacitor c=16.3872a
    C16 (YN\#4 VSS!) capacitor c=2.59084e-18
    C43 (YN\#4 A) capacitor c=300.832a
    C24 (VDD!\#3 A) capacitor c=20.8062a
    C25 (VDD!\#3 A\#2) capacitor c=465.503a
    C32 (VDD!\#3 YN\#4) capacitor c=395.459a
    C36 (VDD!\#3 3) capacitor c=45.3471a
    C44 (YN\#4 A\#2) capacitor c=473.469a
    C60 (YN\#4 Y\#5) capacitor c=12.1626a
    C78 (YN\#4 3) capacitor c=2.19804e-15
    C51 (A\#2 8) capacitor c=531.582a
    C41 (VDD!\#3 8) capacitor c=803.227a
    C33 (3 VDD!) capacitor c=8.99848e-15
    C40 (8 VDD!) capacitor c=36.7943a
    C85 (YN\#4 8) capacitor c=181.312a
    C7 (Y VSS!) capacitor c=11.9486a
    C59 (YN\#4 Y) capacitor c=12.6835a
    C64 (3 Y) capacitor c=3.21879e-15
    C9 (YN\#5 VSS!) capacitor c=8.1593e-19
    C72 (YN\#5 3) capacitor c=1.21834e-15
    C10 (YN\#2311 VSS!) capacitor c=7.16737e-18
    C55 (Y\#5 YN\#2311) capacitor c=456.232a
    C73 (YN\#2311 3) capacitor c=1.24282e-15
    C17 (VSS!\#3 YN\#3) capacitor c=226.76a
    C45 (YN\#3 A\#4) capacitor c=209.049a
    C79 (YN\#3 3) capacitor c=226.641a
    C30 (VDD!\#4 YN) capacitor c=9.4262e-18
    C52 (YN Y) capacitor c=637.311a
    C71 (3 YN) capacitor c=4.52833e-15
    C61 (YN\#3 Y\#3) capacitor c=3.0414e-18
    C68 (Y\#3 3) capacitor c=315.719a
    C8 (Y\#3 VSS!\#1) capacitor c=478.259a
    C21 (VSS!\#1 3) capacitor c=5.72766e-15
    C14 (VSS!\#4 YN) capacitor c=60.126a
    C22 (VSS!\#4 3) capacitor c=186.57a
    C84 (YN\#2313 6) capacitor c=522.726a
    C37 (6 VDD!) capacitor c=36.7943a
    C28 (VDD!\#1 YN\#5) capacitor c=430.104a
    C29 (VDD!\#1 YN\#2311) capacitor c=428.658a
    C34 (VDD!\#1 3) capacitor c=5.59392e-15
    C38 (VDD!\#1 6) capacitor c=154.573a
    C39 (VDD!\#4 6) capacitor c=149.256a
    C70 (Y\#5 6) capacitor c=151.872a
    C82 (YN\#5 6) capacitor c=481.565a
    C83 (YN\#2311 6) capacitor c=511.031a
    C69 (Y\#1 6) capacitor c=802.537a
    C19 (YN\#7 VSS!\#1) capacitor c=24.5945a
    C26 (VDD!\#1 Y\#1) capacitor c=303.361a
    C53 (Y\#1 YN\#5) capacitor c=468.463a
    C18 (YN\#6 VSS!\#1) capacitor c=24.2067a
    C62 (YN\#6 Y) capacitor c=767.135a
    C63 (YN\#7 Y) capacitor c=1.0515e-15
    C65 (Y\#1 3) capacitor c=279.493a
    C80 (YN\#6 3) capacitor c=2.82269e-15
    C81 (YN\#7 3) capacitor c=3.4762e-15
    C12 (VSS!\#1 YN\#9) capacitor c=277.978a
    C75 (YN\#9 3) capacitor c=717.713a
    C54 (Y\#4 YN\#9) capacitor c=212.81a
    C66 (Y\#4 3) capacitor c=1.00303e-15
    C13 (VSS!\#1 YN\#2310) capacitor c=281.028a
    C15 (VSS!\#4 YN\#2312) capacitor c=298.818a
    C57 (Y\#3 YN\#2310) capacitor c=200.663a
    C58 (Y\#3 YN\#2312) capacitor c=196.886a
    C76 (YN\#2310 3) capacitor c=745.779a
    C77 (YN\#2312 3) capacitor c=759.789a
    MX6_M0_unmatched (Y\#5 YN\#2313 VDD!\#4 VDD!\#4) pch w=1.2e-05 l=1e-06 \
        as=3.6e-11 ad=0 ps=3e-05 pd=0 sa=2e-06 sb=2e-06
    MM0 (YN\#4 A\#2 VDD!\#3 VDD!\#3) pch w=1.2e-05 l=1e-06 as=0 ad=3e-11 \
        ps=0 pd=2.9e-05 sa=2e-06 sb=2e-06
    MM5 (Y\#5 YN\#2311 VDD!\#1 VDD!\#1) pch w=1.2e-05 l=1e-06 as=0 \
        ad=3.6e-11 ps=0 pd=3e-05 sa=2e-06 sb=2e-06
    MM1 (Y\#1 YN\#5 VDD!\#1 VDD!\#1) pch w=1.2e-05 l=1e-06 as=0 ad=3e-11 \
        ps=0 pd=2.9e-05 sa=2e-06 sb=2e-06
ends BUFX9_analog_extracted
// End of subcircuit definition.

// Library name: KISTA_SOI_STDLIB2
// Cell name: BUFX16
// View name: analog_extracted
subckt BUFX16_analog_extracted A Y
    C21 (YN\#8 VSS!) capacitor c=1.08754e-18
    C59 (Y\#1 VDD!\#1) capacitor c=196.338a
    C63 (VDD!\#1 YN\#8) capacitor c=351.377a
    C107 (Y\#1 YN\#8) capacitor c=411.887a
    C135 (YN\#8 3) capacitor c=1.85673e-15
    C1 (VDD!\#2312 VSS!) capacitor c=44.3057a
    C2 (VDD!\#2314 VSS!) capacitor c=50.1211a
    C3 (A\#2 VSS!) capacitor c=18.6647a
    C90 (A\#2 3) capacitor c=1.26764e-15
    C4 (A\#9 VSS!) capacitor c=6.86256e-18
    C54 (VDD!\#2314 A\#9) capacitor c=328.82a
    C91 (A\#9 3) capacitor c=1.28344e-15
    C5 (A\#2311 VSS!) capacitor c=6.92476e-18
    C55 (VDD!\#2314 A\#2311) capacitor c=328.82a
    C92 (A\#2311 3) capacitor c=1.25579e-15
    C6 (A\#2313 VSS!) capacitor c=8.17135e-18
    C93 (A\#2313 3) capacitor c=1.23855e-15
    C12 (A\#3 VSS!) capacitor c=10.0673a
    C98 (A\#3 3) capacitor c=3.93039e-15
    C13 (A\#4 VSS!) capacitor c=12.3286a
    C99 (A\#4 3) capacitor c=4.6387e-15
    C14 (A\#5 VSS!) capacitor c=11.6825a
    C100 (A\#5 3) capacitor c=4.63684e-15
    C15 (A\#6 VSS!) capacitor c=2.01384e-19
    C101 (A\#6 3) capacitor c=239.767a
    C20 (Y\#3 VSS!) capacitor c=89.1486a
    C132 (Y\#3 3) capacitor c=13.1575f
    C22 (YN\#2319 VSS!) capacitor c=5.96132e-19
    C108 (Y\#1 YN\#2319) capacitor c=419.723a
    C136 (YN\#2319 3) capacitor c=1.97906e-15
    C23 (YN\#21 VSS!) capacitor c=3.20269e-18
    C137 (YN\#21 3) capacitor c=1.9317e-15
    C24 (YN\#23 VSS!) capacitor c=7.25243e-18
    C138 (YN\#23 3) capacitor c=1.97923e-15
    C25 (YN\#25 VSS!) capacitor c=1.4055e-18
    C139 (YN\#25 3) capacitor c=1.9327e-15
    C26 (YN\#27 VSS!) capacitor c=2.97066e-18
    C140 (YN\#27 3) capacitor c=1.97886e-15
    C27 (YN\#29 VSS!) capacitor c=6.13689e-18
    C141 (YN\#29 3) capacitor c=1.93275e-15
    C28 (YN\#31 VSS!) capacitor c=1.1809e-18
    C70 (VDD!\#2312 YN\#31) capacitor c=355.516a
    C142 (YN\#31 3) capacitor c=2.00159e-15
    C38 (YN\#6 VSS!) capacitor c=6.49224e-18
    C71 (VDD!\#2314 YN\#6) capacitor c=345.252a
    C76 (YN\#6 A\#2) capacitor c=347.332a
    C77 (YN\#6 A\#9) capacitor c=353.982a
    C103 (A\#9 8) capacitor c=510.919a
    C52 (8 VSS!) capacitor c=2.866e-18
    C102 (A\#2 8) capacitor c=496.373a
    C104 (A\#2311 8) capacitor c=510.854a
    C105 (A\#2313 8) capacitor c=509.939a
    C166 (YN\#6 8) capacitor c=327.123a
    C75 (VDD!\#8 8) capacitor c=925.259a
    C57 (VDD!\#8 A\#2313) capacitor c=345.416a
    C58 (A\#6 VDD!\#8) capacitor c=3.82381e-19
    C40 (YN\#7 VSS!) capacitor c=6.99341e-18
    C72 (YN\#7 VDD!\#2314) capacitor c=345.252a
    C80 (YN\#7 A\#2311) capacitor c=353.335a
    C81 (YN\#7 A\#2313) capacitor c=345.178a
    C42 (YN\#2 VSS!) capacitor c=35.2449a
    C85 (YN\#2 A\#3) capacitor c=1.16015e-15
    C86 (YN\#2 A\#4) capacitor c=1.21632e-15
    C87 (YN\#2 A\#5) capacitor c=1.22191e-15
    C88 (YN\#2 A\#6) capacitor c=33.9257a
    C94 (A\#7 3) capacitor c=1.68513e-15
    C95 (A\#8 3) capacitor c=1.78505e-15
    C96 (A\#2310 3) capacitor c=1.76035e-15
    C82 (YN\#4 A\#2310) capacitor c=243.851a
    C7 (VSS!\#2313 A\#7) capacitor c=247.256a
    C43 (YN\#2 VSS!\#2313) capacitor c=13.0231a
    C8 (VSS!\#2314 A\#8) capacitor c=232.737a
    C9 (VSS!\#2314 A\#2310) capacitor c=237.367a
    C41 (YN\#4 VSS!\#2314) capacitor c=210.977a
    C39 (VSS!\#2314 YN\#5) capacitor c=241.977a
    C78 (YN\#5 A\#7) capacitor c=254.328a
    C51 (VSS!\#6 3) capacitor c=34.7097f
    C79 (YN\#5 A\#8) capacitor c=251.993a
    C124 (YN\#5 Y\#5) capacitor c=1.72361e-18
    C19 (Y\#5 VSS!\#2311) capacitor c=291.948a
    C34 (VSS!\#2311 YN\#26) capacitor c=230.134a
    C148 (YN\#26 3) capacitor c=1.06796e-15
    C35 (VSS!\#2311 YN\#28) capacitor c=229.324a
    C121 (Y\#5 YN\#28) capacitor c=182.711a
    C149 (YN\#28 3) capacitor c=1.06207e-15
    C50 (YN\#2315 VSS!\#2311) capacitor c=8.58473e-18
    C157 (YN\#2315 3) capacitor c=4.45725e-15
    C44 (YN\#9 VSS!) capacitor c=2.44243e-18
    C125 (YN\#9 Y\#3) capacitor c=726.258a
    C151 (YN\#9 3) capacitor c=3.95354e-15
    C158 (YN\#8 6) capacitor c=481.565a
    C74 (VDD!\#1 6) capacitor c=1.29692e-15
    C159 (YN\#2319 6) capacitor c=510.912a
    C160 (YN\#21 6) capacitor c=510.794a
    C161 (YN\#23 6) capacitor c=510.942a
    C162 (YN\#25 6) capacitor c=510.942a
    C163 (YN\#27 6) capacitor c=510.884a
    C164 (YN\#29 6) capacitor c=511.067a
    C165 (YN\#31 6) capacitor c=524.746a
    C133 (Y\#2311 6) capacitor c=631.387a
    C119 (Y\#2311 YN\#29) capacitor c=419.452a
    C120 (Y\#2311 YN\#31) capacitor c=415.2a
    C123 (YN\#6 Y\#2311) capacitor c=5.17013e-18
    C53 (VDD!\#2313 A\#2) capacitor c=343.735a
    C73 (VDD!\#6 3) capacitor c=33.208f
    C56 (VDD!\#8 A) capacitor c=8.55475e-18
    C10 (VSS!\#8 A) capacitor c=23.8561a
    C84 (YN\#2 A) capacitor c=815.636a
    C89 (3 A) capacitor c=6.06015e-15
    C11 (VSS!\#8 A\#2312) capacitor c=244.186a
    C83 (YN\#4 A\#2312) capacitor c=243.524a
    C97 (A\#2312 3) capacitor c=1.73798e-15
    C134 (3 YN) capacitor c=12.803f
    C122 (Y\#5 YN\#30) capacitor c=180.052a
    C150 (YN\#30 3) capacitor c=1.10811e-15
    C36 (VSS!\#2312 YN) capacitor c=49.9854a
    C106 (YN Y) capacitor c=723.91a
    C37 (VSS!\#2312 YN\#30) capacitor c=245.82a
    C131 (YN\#2315 Y) capacitor c=1.23222e-15
    C49 (YN\#2314 VSS!\#2311) capacitor c=10.328a
    C156 (YN\#2314 3) capacitor c=4.54319e-15
    C130 (YN\#2314 Y\#4) capacitor c=1.27784e-15
    C129 (YN\#2313 Y\#4) capacitor c=1.27383e-15
    C155 (YN\#2313 3) capacitor c=4.49503e-15
    C118 (Y\#9 YN\#26) capacitor c=182.01a
    C62 (VDD!\#4 Y\#2310) capacitor c=53.3005a
    C115 (Y\#2310 YN\#25) capacitor c=418.094a
    C116 (Y\#2310 YN\#27) capacitor c=417.35a
    C18 (Y\#9 VSS!\#2310) capacitor c=209.854a
    C48 (YN\#2313 VSS!\#2310) capacitor c=10.3568a
    C32 (VSS!\#2310 YN\#22) capacitor c=230.44a
    C146 (YN\#22 3) capacitor c=1.06811e-15
    C33 (VSS!\#2310 YN\#24) capacitor c=230.159a
    C117 (Y\#9 YN\#24) capacitor c=181.719a
    C147 (YN\#24 3) capacitor c=1.0619e-15
    C47 (YN\#2312 VSS!\#2310) capacitor c=10.9771a
    C114 (Y\#7 YN\#22) capacitor c=181.719a
    C128 (YN\#2312 Y\#3) capacitor c=1.27737e-15
    C154 (YN\#2312 3) capacitor c=4.54342e-15
    C127 (YN\#2311 Y\#3) capacitor c=1.2758e-15
    C153 (YN\#2311 3) capacitor c=4.49421e-15
    C17 (Y\#7 VSS!\#9) capacitor c=209.854a
    C46 (YN\#2311 VSS!\#9) capacitor c=10.3338a
    C16 (Y\#6 VSS!\#1) capacitor c=132.417a
    C64 (VDD!\#9 YN\#2319) capacitor c=332.879a
    C45 (YN\#2310 VSS!\#9) capacitor c=8.57901e-18
    C65 (VDD!\#9 YN\#21) capacitor c=332.106a
    C126 (YN\#2310 Y\#3) capacitor c=1.28081e-15
    C152 (YN\#2310 3) capacitor c=4.54342e-15
    C29 (VSS!\#1 YN\#2317) capacitor c=243.286a
    C109 (Y\#6 YN\#2317) capacitor c=178.958a
    C143 (YN\#2317 3) capacitor c=1.00015e-15
    C66 (VDD!\#2310 YN\#23) capacitor c=326.539a
    C67 (VDD!\#2310 YN\#25) capacitor c=332.106a
    C68 (VDD!\#2311 YN\#27) capacitor c=332.106a
    C61 (Y\#2311 VDD!\#2311) capacitor c=491.228a
    C69 (VDD!\#2311 YN\#29) capacitor c=326.539a
    C112 (Y\#8 YN\#23) capacitor c=418.655a
    C60 (Y\#8 VDD!\#9) capacitor c=637.204a
    C111 (Y\#8 YN\#21) capacitor c=418.671a
    C30 (VSS!\#9 YN\#2318) capacitor c=230.022a
    C31 (VSS!\#9 YN\#20) capacitor c=230.366a
    C110 (Y\#6 YN\#2318) capacitor c=182.823a
    C144 (YN\#2318 3) capacitor c=1.06798e-15
    C145 (YN\#20 3) capacitor c=1.06153e-15
    C113 (Y\#7 YN\#20) capacitor c=182.462a
    MX3_M0_unmatched (YN\#4 A\#2310 VSS!\#2314 VSS!\#2314) nch w=4e-06 \
        l=1e-06 as=1.2e-11 ad=0 ps=1.4e-05 pd=0 sa=2e-06 sb=2e-06
    MX5_M0_unmatched (YN\#5 A\#7 VSS!\#2313 VSS!\#2313) nch w=4e-06 \
        l=1e-06 as=1.2e-11 ad=0 ps=1.4e-05 pd=0 sa=2e-06 sb=2e-06
    MX4_M0_unmatched (YN\#5 A\#8 VSS!\#2314 VSS!\#2314) nch w=4e-06 \
        l=1e-06 as=1.2e-11 ad=0 ps=1.4e-05 pd=0 sa=2e-06 sb=2e-06
    MX6_M0_unmatched (Y\#5 YN\#28 VSS!\#2311 VSS!\#2311) nch w=4e-06 \
        l=1e-06 as=1.2e-11 ad=0 ps=1.4e-05 pd=0 sa=2e-06 sb=2e-06
    MX2_M0_unmatched (YN\#4 A\#2312 VSS!\#8 VSS!\#8) nch w=4e-06 l=1e-06 \
        as=1.2e-11 ad=0 ps=1.4e-05 pd=0 sa=2e-06 sb=2e-06
    MX25_M0_unmatched (Y\#5 YN\#30 VSS!\#2312 VSS!\#2312) nch w=4e-06 \
        l=1e-06 as=1.2e-11 ad=0 ps=1.4e-05 pd=0 sa=2e-06 sb=2e-06
    MX7_M0_unmatched (Y\#9 YN\#26 VSS!\#2311 VSS!\#2311) nch w=4e-06 \
        l=1e-06 as=1.2e-11 ad=0 ps=1.4e-05 pd=0 sa=2e-06 sb=2e-06
    MX8_M0_unmatched (Y\#9 YN\#24 VSS!\#2310 VSS!\#2310) nch w=4e-06 \
        l=1e-06 as=1.2e-11 ad=0 ps=1.4e-05 pd=0 sa=2e-06 sb=2e-06
    MX9_M0_unmatched (Y\#7 YN\#22 VSS!\#2310 VSS!\#2310) nch w=4e-06 \
        l=1e-06 as=1.2e-11 ad=0 ps=1.4e-05 pd=0 sa=2e-06 sb=2e-06
    MX12_M0_unmatched (Y\#6 YN\#2317 VSS!\#1 VSS!\#1) nch w=4e-06 l=1e-06 \
        as=1.2e-11 ad=0 ps=1.4e-05 pd=0 sa=2e-06 sb=2e-06
    MX11_M0_unmatched (Y\#6 YN\#2318 VSS!\#9 VSS!\#9) nch w=4e-06 l=1e-06 \
        as=1.2e-11 ad=0 ps=1.4e-05 pd=0 sa=2e-06 sb=2e-06
    MX10_M0_unmatched (Y\#7 YN\#20 VSS!\#9 VSS!\#9) nch w=4e-06 l=1e-06 \
        as=1.2e-11 ad=0 ps=1.4e-05 pd=0 sa=2e-06 sb=2e-06
    Rs1 (3 VSS!) resistor r=50
    Rd13 (A\#2 A\#3) resistor r=1336.0317
    Rd22 (A\#3 A\#4) resistor r=258.7097
    Rc6 (A\#4 A\#9) resistor r=1327.5659
    Rd23 (A\#5 A\#2311) resistor r=1327.5659
    Rc5 (A\#4 A\#5) resistor r=292.3445
    Rd14 (A\#5 A\#6) resistor r=292.3445
    Rc4 (A\#6 A\#2313) resistor r=1327.5659
    Rc8 (Y\#1 Y\#3) resistor r=1.8435
    Rc2 (A\#3 A\#7) resistor r=1336.0317
    Rd24 (A\#4 A\#8) resistor r=1327.5659
    Rc7 (A\#5 A\#2310) resistor r=1327.5659
    Rc46 (YN\#2 YN\#6) resistor r=1.668
    Rc38 (YN\#2 YN\#7) resistor r=1.9537
    Rc26 (YN\#7 YN\#4) resistor r=30.2634
    Rd36 (YN\#2 YN\#4) resistor r=3.1213
    Rc30 (VSS! VSS!\#2314) resistor r=5.3242
    Rc21 (VSS!\#6 VSS!\#2313) resistor r=2.6224
    Rd7 (VSS!\#6 VSS!\#2314) resistor r=5.2977
    Rd19 (YN\#2 YN\#5) resistor r=2.668
    Rd8 (VSS! VSS!\#6) resistor r=0.134
    Rc45 (YN\#2315 YN\#28) resistor r=727.5659
    Rd31 (YN\#2315 YN\#29) resistor r=1927.5659
    Rd35 (VSS! VSS!\#8) resistor r=2.6222
    Rd25 (YN\#8 YN\#9) resistor r=1936.0317
    Rc22 (VDD!\#1 VDD!\#2) resistor r=1.4962
    Rc24 (VDD!\#6 VDD!\#2313) resistor r=1.4224
    Rd5 (VDD!\#6 VDD!\#2314) resistor r=2.9037
    Rc1 (VDD! VDD!\#2314) resistor r=2.9182
    Rd2 (VDD! VDD!\#8) resistor r=1.4222
    Rd11 (VDD! VDD!\#6) resistor r=135.4m
    Rd33 (YN YN\#2) resistor r=5.193
    Rc3 (A\#6 A) resistor r=119.1987
    Rd26 (A\#6 A\#2312) resistor r=1327.5659
    Rc32 (VDD!\#2312 VDD!\#6) resistor r=2.1591
    Rd12 (VDD!\#4 VDD!\#6) resistor r=100.2m
    Rd9 (VDD!\#2 VDD!\#4) resistor r=135.1m
    Rc25 (VDD!\#4 VDD!\#2312) resistor r=4.3619
    Rc37 (YN\#2316 YN\#31) resistor r=1927.5659
    Rd18 (YN\#2315 YN\#2316) resistor r=292.3445
    Rc39 (YN\#2316 YN) resistor r=114.0987
    Rd34 (YN\#2316 YN\#30) resistor r=727.5659
    Rc18 (Y Y\#5) resistor r=2.775
    Rc36 (YN\#2314 YN\#2315) resistor r=292.3445
    Rd32 (YN\#2314 YN\#26) resistor r=727.5659
    Rd4 (Y Y\#2311) resistor r=1.575
    Rc9 (Y Y\#4) resistor r=0.193
    Rc44 (YN\#2314 YN\#27) resistor r=1927.5659
    Rd17 (YN\#2313 YN\#2314) resistor r=292.3445
    Rd29 (YN\#2313 YN\#25) resistor r=1927.5659
    Rc29 (VSS!\#2312 VSS!\#6) resistor r=3.9531
    Rd6 (VSS!\#4 VSS!\#6) resistor r=99.5m
    Rc20 (VSS!\#4 VSS!\#2312) resistor r=7.9861
    Rd1 (VSS!\#4 VSS!\#2311) resistor r=2.6224
    Rc11 (Y\#3 Y\#4) resistor r=0.186
    Rc16 (Y\#4 Y\#9) resistor r=2.768
    Rc17 (Y\#4 Y\#2310) resistor r=1.568
    Rc28 (VSS!\#2310 VSS!\#4) resistor r=5.3108
    Rd20 (VSS!\#2 VSS!\#4) resistor r=133.7m
    Rc27 (VSS!\#2 VSS!\#2310) resistor r=5.3108
    Rc35 (YN\#2313 YN\#24) resistor r=727.5659
    Rc43 (YN\#2312 YN\#2313) resistor r=292.3445
    Rd30 (YN\#2312 YN\#22) resistor r=727.5659
    Rc34 (YN\#2312 YN\#23) resistor r=1927.5659
    Rd16 (YN\#2311 YN\#2312) resistor r=292.3445
    Rd27 (YN\#2311 YN\#21) resistor r=1927.5659
    Rc14 (Y\#3 Y\#7) resistor r=2.768
    Rd21 (VSS!\#2 VSS!\#9) resistor r=2.6224
    Rc19 (VSS!\#1 VSS!\#2) resistor r=2.6962
    Rc12 (Y\#1 Y\#6) resistor r=29.6259
    Rc33 (YN\#2310 YN\#2319) resistor r=1927.5659
    Rd15 (YN\#9 YN\#2310) resistor r=258.7097
    Rc40 (YN\#9 YN\#2317) resistor r=736.0318
    Rd10 (VDD!\#2 VDD!\#9) resistor r=1.4224
    Rc31 (VDD!\#2 VDD!\#2310) resistor r=2.9108
    Rd3 (VDD!\#4 VDD!\#2311) resistor r=1.4224
    Rc23 (VDD!\#2310 VDD!\#4) resistor r=2.9108
    Rc15 (Y\#3 Y\#8) resistor r=1.568
    Rc13 (Y\#6 Y\#3) resistor r=3.2498
    Rc41 (YN\#2310 YN\#2311) resistor r=292.3445
    Rd28 (YN\#2310 YN\#2318) resistor r=727.5659
    Rc42 (YN\#2311 YN\#20) resistor r=727.5659
    MX24_M0_unmatched (Y\#1 YN\#8 VDD!\#1 VDD!\#1) pch w=8e-06 l=1e-06 \
        as=0 ad=2.4e-11 ps=0 pd=2.2e-05 sa=2e-06 sb=2e-06
    MX16_M0_unmatched (YN\#6 A\#9 VDD!\#2314 VDD!\#2314) pch w=8e-06 \
        l=1e-06 as=0 ad=2.4e-11 ps=0 pd=2.2e-05 sa=2e-06 sb=2e-06
    MX15_M0_unmatched (YN\#7 A\#2311 VDD!\#2314 VDD!\#2314) pch w=8e-06 \
        l=1e-06 as=0 ad=2.4e-11 ps=0 pd=2.2e-05 sa=2e-06 sb=2e-06
    MX14_M0_unmatched (YN\#7 A\#2313 VDD!\#8 VDD!\#8) pch w=8e-06 l=1e-06 \
        as=0 ad=2.4e-11 ps=0 pd=2.2e-05 sa=2e-06 sb=2e-06
    MX17_M0_unmatched (YN\#6 A\#2 VDD!\#2313 VDD!\#2313) pch w=8e-06 \
        l=1e-06 as=0 ad=2.4e-11 ps=0 pd=2.2e-05 sa=2e-06 sb=2e-06
    MX13_M0_unmatched (Y\#2311 YN\#31 VDD!\#2312 VDD!\#2312) pch w=8e-06 \
        l=1e-06 as=2.4e-11 ad=0 ps=2.2e-05 pd=0 sa=2e-06 sb=2e-06
    MX23_M0_unmatched (Y\#1 YN\#2319 VDD!\#9 VDD!\#9) pch w=8e-06 l=1e-06 \
        as=0 ad=2.4e-11 ps=0 pd=2.2e-05 sa=2e-06 sb=2e-06
    MX20_M0_unmatched (Y\#2310 YN\#25 VDD!\#2310 VDD!\#2310) pch w=8e-06 \
        l=1e-06 as=0 ad=2.4e-11 ps=0 pd=2.2e-05 sa=2e-06 sb=2e-06
    MX19_M0_unmatched (Y\#2310 YN\#27 VDD!\#2311 VDD!\#2311) pch w=8e-06 \
        l=1e-06 as=0 ad=2.4e-11 ps=0 pd=2.2e-05 sa=2e-06 sb=2e-06
    MX18_M0_unmatched (Y\#2311 YN\#29 VDD!\#2311 VDD!\#2311) pch w=8e-06 \
        l=1e-06 as=0 ad=2.4e-11 ps=0 pd=2.2e-05 sa=2e-06 sb=2e-06
    MX21_M0_unmatched (Y\#8 YN\#23 VDD!\#2310 VDD!\#2310) pch w=8e-06 \
        l=1e-06 as=0 ad=2.4e-11 ps=0 pd=2.2e-05 sa=2e-06 sb=2e-06
    MX22_M0_unmatched (Y\#8 YN\#21 VDD!\#9 VDD!\#9) pch w=8e-06 l=1e-06 \
        as=0 ad=2.4e-11 ps=0 pd=2.2e-05 sa=2e-06 sb=2e-06
ends BUFX16_analog_extracted
// End of subcircuit definition.

// Library name: KISTA_SOI_STDLIB2
// Cell name: BUFX27
// View name: analog_extracted
subckt BUFX27_analog_extracted A Y
    C27 (YN\#34 VSS!) capacitor c=4.61564e-18
    C58 (VDD!\#2311 Y\#2314) capacitor c=484.497a
    C68 (VDD!\#2311 YN\#34) capacitor c=458.508a
    C115 (Y\#2314 YN\#34) capacitor c=381.033a
    C145 (YN\#34 3) capacitor c=590.969a
    C1 (VDD!\#8 VSS!) capacitor c=89.9849a
    C2 (A\#2 VSS!) capacitor c=8.76319e-18
    C93 (A\#2 3) capacitor c=1.24136e-15
    C3 (A\#8 VSS!) capacitor c=10.9466a
    C94 (A\#8 3) capacitor c=1.24325e-15
    C4 (A\#2310 VSS!) capacitor c=9.55994e-18
    C95 (A\#2310 3) capacitor c=1.23857e-15
    C18 (Y\#3 VSS!) capacitor c=105.081a
    C134 (Y\#3 3) capacitor c=11.5946f
    C19 (YN\#8 VSS!) capacitor c=8.1593e-19
    C137 (YN\#8 3) capacitor c=573.482a
    C20 (YN\#20 VSS!) capacitor c=7.96235e-18
    C138 (YN\#20 3) capacitor c=580.248a
    C21 (YN\#22 VSS!) capacitor c=1.68614e-18
    C61 (VDD!\#8 YN\#22) capacitor c=437.835a
    C139 (YN\#22 3) capacitor c=589.437a
    C22 (YN\#24 VSS!) capacitor c=8.77972e-18
    C62 (VDD!\#8 YN\#24) capacitor c=430.11a
    C140 (YN\#24 3) capacitor c=580.259a
    C23 (YN\#26 VSS!) capacitor c=8.55848e-18
    C141 (YN\#26 3) capacitor c=589.567a
    C24 (YN\#28 VSS!) capacitor c=1.39111e-18
    C142 (YN\#28 3) capacitor c=580.259a
    C25 (YN\#30 VSS!) capacitor c=8.55848e-18
    C143 (YN\#30 3) capacitor c=589.567a
    C26 (YN\#32 VSS!) capacitor c=5.96132e-19
    C114 (Y\#2314 YN\#32) capacitor c=387.469a
    C144 (YN\#32 3) capacitor c=580.303a
    C38 (YN\#6 VSS!) capacitor c=1.08809e-18
    C82 (YN\#6 A\#2) capacitor c=463.741a
    C117 (YN\#6 Y\#2314) capacitor c=10.946a
    C41 (YN\#2 VSS!) capacitor c=13.9195a
    C42 (YN\#9 VSS!) capacitor c=1.75513e-18
    C123 (Y\#3 YN\#9) capacitor c=529.841a
    C155 (YN\#9 3) capacitor c=2.85699e-15
    C43 (YN\#2310 VSS!) capacitor c=2.89948e-18
    C124 (Y\#3 YN\#2310) capacitor c=926.292a
    C156 (YN\#2310 3) capacitor c=3.5348e-15
    C44 (YN\#2311 VSS!) capacitor c=4.99602e-18
    C73 (YN\#2311 VDD!\#8) capacitor c=7.76363e-18
    C125 (Y\#3 YN\#2311) capacitor c=927.59a
    C157 (YN\#2311 3) capacitor c=3.55946e-15
    C45 (YN\#2312 VSS!) capacitor c=4.58407e-18
    C74 (YN\#2312 VDD!\#8) capacitor c=7.76881e-18
    C158 (YN\#2312 3) capacitor c=3.52971e-15
    C122 (Y\#3 YN\#21) capacitor c=505.599a
    C148 (YN\#21 3) capacitor c=1.33344e-15
    C30 (VSS!\#8 YN\#21) capacitor c=282.925a
    C13 (VSS!\#8 Y\#8) capacitor c=301.869a
    C29 (VSS!\#1 YN\#2319) capacitor c=282.586a
    C121 (Y\#3 YN\#2319) capacitor c=503.224a
    C147 (YN\#2319 3) capacitor c=1.32433e-15
    C72 (YN\#2310 VDD!\#1) capacitor c=7.79309e-18
    C59 (VDD!\#1 YN\#8) capacitor c=432.385a
    C60 (VDD!\#1 YN\#20) capacitor c=430.939a
    C71 (YN\#9 VDD!\#1) capacitor c=7.77798e-18
    C28 (VSS!\#1 YN\#2318) capacitor c=278.802a
    C120 (Y\#3 YN\#2318) capacitor c=519.145a
    C146 (YN\#2318 3) capacitor c=1.28726e-15
    C12 (VSS!\#1 Y\#7) capacitor c=168.537a
    C107 (Y\#1 YN\#8) capacitor c=411.934a
    C135 (Y\#1 6) capacitor c=1.41081e-15
    C163 (YN\#8 6) capacitor c=481.565a
    C51 (6 VSS!) capacitor c=2.866e-18
    C80 (VDD!\#1 6) capacitor c=766.361a
    C164 (YN\#20 6) capacitor c=510.912a
    C165 (YN\#22 6) capacitor c=510.794a
    C166 (YN\#24 6) capacitor c=510.942a
    C167 (YN\#26 6) capacitor c=510.942a
    C168 (YN\#28 6) capacitor c=510.942a
    C169 (YN\#30 6) capacitor c=510.942a
    C170 (YN\#32 6) capacitor c=511.061a
    C171 (YN\#34 6) capacitor c=522.809a
    C31 (VSS!\#8 YN\#23) capacitor c=282.353a
    C149 (YN\#23 3) capacitor c=1.32442e-15
    C126 (Y\#4 YN\#23) capacitor c=502.687a
    C128 (Y\#4 YN\#2312) capacitor c=926.97a
    C46 (YN\#2313 VSS!) capacitor c=2.85058e-18
    C129 (Y\#4 YN\#2313) capacitor c=929.322a
    C159 (YN\#2313 3) capacitor c=3.55946e-15
    C56 (Y\#9 VDD!\#1) capacitor c=757.406a
    C108 (Y\#9 YN\#20) capacitor c=388.528a
    C109 (Y\#9 YN\#22) capacitor c=387.469a
    C110 (Y\#2311 YN\#24) capacitor c=387.469a
    C111 (Y\#2311 YN\#26) capacitor c=387.469a
    C14 (VSS!\#9 Y\#2310) capacitor c=285.431a
    C32 (VSS!\#9 YN\#25) capacitor c=282.131a
    C127 (Y\#4 YN\#25) capacitor c=505.599a
    C150 (YN\#25 3) capacitor c=1.33372e-15
    C50 (VSS!\#4 3) capacitor c=34.3258f
    C15 (Y\#2312 VSS!\#9) capacitor c=285.577a
    C33 (VSS!\#9 YN\#27) capacitor c=282.131a
    C130 (Y\#5 YN\#27) capacitor c=502.687a
    C151 (YN\#27 3) capacitor c=1.32442e-15
    C47 (YN\#2314 VSS!) capacitor c=2.84309e-18
    C132 (Y\#5 YN\#2314) capacitor c=928.703a
    C160 (YN\#2314 3) capacitor c=3.52971e-15
    C75 (YN\#2313 VDD!\#9) capacitor c=7.76363e-18
    C57 (VDD!\#9 Y\#2311) capacitor c=965.528a
    C63 (VDD!\#9 YN\#26) capacitor c=430.11a
    C64 (VDD!\#9 YN\#28) capacitor c=437.278a
    C76 (YN\#2314 VDD!\#9) capacitor c=7.76881e-18
    C48 (YN\#2315 VSS!) capacitor c=4.56247e-18
    C133 (Y\#5 YN\#2315) capacitor c=927.59a
    C161 (YN\#2315 3) capacitor c=3.55947e-15
    C79 (VDD!\#4 3) capacitor c=32.726f
    C112 (Y\#2313 YN\#28) capacitor c=387.469a
    C113 (Y\#2313 YN\#30) capacitor c=387.469a
    C65 (VDD!\#2310 YN\#30) capacitor c=430.11a
    C66 (VDD!\#2310 YN\#32) capacitor c=437.278a
    C77 (YN\#2315 VDD!\#2310) capacitor c=7.76363e-18
    C67 (VDD!\#2311 YN) capacitor c=26.7162a
    C136 (3 YN) capacitor c=8.86597e-15
    C78 (YN\#2316 VDD!\#2310) capacitor c=7.76881e-18
    C49 (YN\#2316 VSS!) capacitor c=1.73861e-18
    C105 (YN Y) capacitor c=616.592a
    C36 (VSS!\#2311 YN) capacitor c=17.282a
    C119 (YN\#2316 Y) capacitor c=943.655a
    C162 (YN\#2316 3) capacitor c=3.57164e-15
    C37 (VSS!\#2311 YN\#33) capacitor c=298.727a
    C154 (YN\#33 3) capacitor c=1.45761e-15
    C131 (Y\#5 YN\#29) capacitor c=505.599a
    C16 (VSS!\#2310 Y) capacitor c=53.023a
    C34 (VSS!\#2310 YN\#29) capacitor c=282.131a
    C152 (YN\#29 3) capacitor c=1.33372e-15
    C35 (VSS!\#2310 YN\#31) capacitor c=281.495a
    C106 (YN\#31 Y) capacitor c=481.087a
    C153 (YN\#31 3) capacitor c=1.30568e-15
    C17 (VSS!\#2311 Y\#6) capacitor c=273.578a
    C116 (Y\#6 YN\#33) capacitor c=261.918a
    C118 (YN\#5 Y) capacitor c=14.3768a
    C39 (VSS!\#2312 YN\#5) capacitor c=251.754a
    C5 (VSS!\#2312 A\#6) capacitor c=290.84a
    C83 (YN\#5 A\#6) capacitor c=207.38a
    C96 (A\#6 3) capacitor c=783.097a
    C9 (A\#3 VSS!\#2312) capacitor c=29.3036a
    C89 (YN\#2 A\#3) capacitor c=767.076a
    C99 (A\#3 3) capacitor c=2.82235e-15
    C10 (A\#4 VSS!\#2312) capacitor c=23.8513a
    C90 (YN\#2 A\#4) capacitor c=1.05054e-15
    C100 (A\#4 3) capacitor c=3.47152e-15
    C6 (VSS!\#2312 A\#7) capacitor c=285.564a
    C97 (A\#7 3) capacitor c=745.686a
    C11 (A\#5 VSS!\#7) capacitor c=2.49641e-18
    C91 (YN\#2 A\#5) capacitor c=29.598a
    C101 (A\#5 3) capacitor c=193.515a
    C7 (VSS!\#7 A) capacitor c=55.8505a
    C88 (YN\#2 A) capacitor c=718.815a
    C92 (3 A) capacitor c=5.01671e-15
    C98 (A\#9 3) capacitor c=743.858a
    C8 (VSS!\#7 A\#9) capacitor c=297.349a
    C40 (YN\#4 VSS!\#2312) capacitor c=286.98a
    C86 (YN\#4 A\#7) capacitor c=196.633a
    C87 (YN\#4 A\#9) capacitor c=197.487a
    C54 (VDD!\#7 A) capacitor c=20.8062a
    C55 (VDD!\#7 A\#2310) capacitor c=452.992a
    C70 (VDD!\#7 YN\#7) capacitor c=480.65a
    C84 (YN\#7 A\#8) capacitor c=454.29a
    C85 (YN\#7 A\#2310) capacitor c=446.799a
    C104 (A\#2310 8) capacitor c=509.939a
    C81 (VDD!\#7 8) capacitor c=991.211a
    C52 (VDD!\#2312 A\#2) capacitor c=439.759a
    C53 (VDD!\#2312 A\#8) capacitor c=427.83a
    C69 (VDD!\#2312 YN\#6) capacitor c=423.679a
    C102 (A\#2 8) capacitor c=517.761a
    C103 (A\#8 8) capacitor c=511.031a
    C172 (YN\#7 8) capacitor c=303.83a
    MX14_M0_unmatched (Y\#2314 YN\#34 VDD!\#2311 VDD!\#2311) pch w=1.2e-05 \
        l=1e-06 as=3.6e-11 ad=0 ps=3e-05 pd=0 sa=2e-06 sb=2e-06
    MM1 (Y\#1 YN\#8 VDD!\#1 VDD!\#1) pch w=1.2e-05 l=1e-06 as=0 ad=3e-11 \
        ps=0 pd=2.9e-05 sa=2e-06 sb=2e-06
    MM5 (Y\#9 YN\#20 VDD!\#1 VDD!\#1) pch w=1.2e-05 l=1e-06 as=0 \
        ad=3.6e-11 ps=0 pd=3e-05 sa=2e-06 sb=2e-06
    MM6 (Y\#9 YN\#22 VDD!\#8 VDD!\#8) pch w=1.2e-05 l=1e-06 as=0 \
        ad=3.6e-11 ps=0 pd=3e-05 sa=2e-06 sb=2e-06
    MM25 (Y\#2311 YN\#24 VDD!\#8 VDD!\#8) pch w=1.2e-05 l=1e-06 as=0 \
        ad=3.6e-11 ps=0 pd=3e-05 sa=2e-06 sb=2e-06
    MM24 (Y\#2311 YN\#26 VDD!\#9 VDD!\#9) pch w=1.2e-05 l=1e-06 as=0 \
        ad=3.6e-11 ps=0 pd=3e-05 sa=2e-06 sb=2e-06
    MM23 (Y\#2313 YN\#28 VDD!\#9 VDD!\#9) pch w=1.2e-05 l=1e-06 as=0 \
        ad=3.6e-11 ps=0 pd=3e-05 sa=2e-06 sb=2e-06
    MM19 (Y\#2313 YN\#30 VDD!\#2310 VDD!\#2310) pch w=1.2e-05 l=1e-06 as=0 \
        ad=3.6e-11 ps=0 pd=3e-05 sa=2e-06 sb=2e-06
    MM18 (Y\#2314 YN\#32 VDD!\#2310 VDD!\#2310) pch w=1.2e-05 l=1e-06 as=0 \
        ad=3.6e-11 ps=0 pd=3e-05 sa=2e-06 sb=2e-06
    MM31 (YN\#7 A\#2310 VDD!\#7 VDD!\#7) pch w=1.2e-05 l=1e-06 as=0 \
        ad=3.6e-11 ps=0 pd=3e-05 sa=2e-06 sb=2e-06
    MM0 (YN\#6 A\#2 VDD!\#2312 VDD!\#2312) pch w=1.2e-05 l=1e-06 as=0 \
        ad=3e-11 ps=0 pd=2.9e-05 sa=2e-06 sb=2e-06
    MM30 (YN\#7 A\#8 VDD!\#2312 VDD!\#2312) pch w=1.2e-05 l=1e-06 as=0 \
        ad=3.6e-11 ps=0 pd=3e-05 sa=2e-06 sb=2e-06
    Rd4 (VDD! VDD!\#7) resistor r=1.0556
    Rc25 (VDD! VDD!\#6) resistor r=66.34m
    Rs1 (3 VSS!) resistor r=50
    Rc19 (YN\#2 YN\#6) resistor r=1.1013
    Rc4 (YN\#8 YN\#9) resistor r=736.0318
    Rd23 (YN\#2310 YN\#20) resistor r=727.5659
    Rc3 (YN\#9 YN\#2310) resistor r=258.7097
    Rd12 (YN\#2310 YN\#2311) resistor r=292.3445
    Rc13 (YN\#2311 YN\#22) resistor r=727.5659
    Rd25 (YN\#2312 YN\#24) resistor r=727.5659
    Rc8 (YN\#2311 YN\#2312) resistor r=292.3445
    Rd26 (YN\#2311 YN\#21) resistor r=1027.5659
    Rd35 (Y\#3 Y\#8) resistor r=1.8097
    Rc21 (YN\#2310 YN\#2319) resistor r=1027.5659
    Rd24 (YN\#9 YN\#2318) resistor r=1036.0317
    Rc37 (VSS!\#1 VSS!\#2) resistor r=1.8878
    Rd36 (Y\#7 Y\#3) resistor r=2.2469
    Rd17 (Y\#1 Y\#7) resistor r=15.7086
    Rd7 (VSS!\#2 VSS!\#8) resistor r=1.8141
    Rc41 (Y\#1 Y\#3) resistor r=1.4937
    Rc12 (YN\#2317 YN\#34) resistor r=727.5659
    Rc14 (YN\#2312 YN\#23) resistor r=1027.5659
    Rd13 (YN\#2312 YN\#2313) resistor r=292.3445
    Rc16 (YN\#2313 YN\#26) resistor r=727.5659
    Rc35 (Y\#3 Y\#4) resistor r=0.186
    Rc42 (Y\#3 Y\#9) resistor r=1.2013
    Rc29 (VDD!\#1 VDD!\#2) resistor r=1.1295
    Rd3 (VDD!\#2 VDD!\#8) resistor r=1.0557
    Rd19 (Y\#4 Y\#2311) resistor r=1.2013
    Rc43 (Y\#4 Y\#2310) resistor r=1.8097
    Rc36 (Y\#4 Y\#5) resistor r=0.186
    Rd28 (YN\#2313 YN\#25) resistor r=1027.5659
    Rc39 (VSS!\#2 VSS!\#9) resistor r=3.6941
    Rd6 (VSS!\#2 VSS!\#4) resistor r=134.4m
    Rc45 (VSS!\#9 VSS!\#4) resistor r=3.6941
    Rc44 (Y\#5 Y\#2312) resistor r=1.8097
    Rc9 (YN\#2314 YN\#27) resistor r=1027.5659
    Rd27 (YN\#2314 YN\#28) resistor r=727.5659
    Rc15 (YN\#2313 YN\#2314) resistor r=292.3445
    Rd14 (YN\#2314 YN\#2315) resistor r=292.3445
    Rc18 (YN\#2315 YN\#30) resistor r=727.5659
    Rc30 (VDD!\#2 VDD!\#9) resistor r=2.1774
    Rc23 (VDD!\#2 VDD!\#4) resistor r=136.1m
    Rc31 (VDD!\#9 VDD!\#4) resistor r=2.1774
    Rd1 (Y\#5 Y\#2313) resistor r=1.2013
    Rc24 (VDD!\#4 VDD!\#2310) resistor r=1.0557
    Rc32 (VDD!\#4 VDD!\#2311) resistor r=2.1774
    Rc27 (VDD!\#4 VDD!\#6) resistor r=136.1m
    Rc33 (VDD!\#2311 VDD!\#6) resistor r=2.1774
    Rd31 (YN YN\#2) resistor r=5.093
    Rc20 (YN\#2317 YN) resistor r=114.0987
    Rd29 (YN\#2316 YN\#32) resistor r=727.5659
    Rd33 (Y Y\#2314) resistor r=1.2083
    Rd15 (YN\#2316 YN\#2317) resistor r=292.3445
    Rd32 (YN\#2317 YN\#33) resistor r=1027.5659
    Rd18 (Y Y\#5) resistor r=0.193
    Rd30 (YN\#2315 YN\#29) resistor r=1027.5659
    Rc17 (YN\#2315 YN\#2316) resistor r=292.3445
    Rc10 (YN\#2316 YN\#31) resistor r=1027.5659
    Rd2 (VSS!\#4 VSS!\#2310) resistor r=1.8141
    Rc34 (Y Y\#6) resistor r=1.8167
    Rd16 (YN\#2 YN\#5) resistor r=1.9097
    Rc38 (VSS!\#4 VSS!\#2311) resistor r=3.6941
    Rd8 (VSS!\#2311 VSS!\#6) resistor r=3.6941
    Rc28 (VSS!\#4 VSS!\#6) resistor r=134.4m
    Rd9 (VSS! VSS!\#6) resistor r=66.34m
    Rd5 (VSS! VSS!\#7) resistor r=1.8139
    Rc22 (VSS!\#6 VSS!\#2312) resistor r=1.8141
    Rc2 (A\#3 A\#6) resistor r=436.0318
    Rd10 (A\#2 A\#3) resistor r=1336.0317
    Rd20 (A\#3 A\#4) resistor r=258.7097
    Rc6 (A\#4 A\#8) resistor r=1327.5659
    Rd22 (A\#4 A\#7) resistor r=427.5659
    Rc5 (A\#4 A\#5) resistor r=292.3445
    Rd21 (A\#5 A\#2310) resistor r=1327.5659
    Rc7 (A\#5 A\#9) resistor r=427.5659
    Rd11 (A\#5 A) resistor r=119.1987
    Rd34 (YN\#2 YN\#4) resistor r=2.3859
    Rc11 (YN\#2 YN\#7) resistor r=1.3787
    Rc40 (YN\#7 YN\#4) resistor r=15.2981
    Rc26 (VDD!\#6 VDD!\#2312) resistor r=1.0557
    MM7 (Y\#8 YN\#21 VSS!\#8 VSS!\#8) nch w=6e-06 l=1e-06 as=0 ad=1.8e-11 \
        ps=0 pd=1.8e-05 sa=2e-06 sb=2e-06
    MM4 (Y\#8 YN\#2319 VSS!\#1 VSS!\#1) nch w=6e-06 l=1e-06 as=0 \
        ad=1.8e-11 ps=0 pd=1.8e-05 sa=2e-06 sb=2e-06
    MM3 (Y\#7 YN\#2318 VSS!\#1 VSS!\#1) nch w=6e-06 l=1e-06 as=0 \
        ad=1.5e-11 ps=0 pd=1.7e-05 sa=2e-06 sb=2e-06
    MM28 (Y\#2310 YN\#23 VSS!\#8 VSS!\#8) nch w=6e-06 l=1e-06 as=0 \
        ad=1.8e-11 ps=0 pd=1.8e-05 sa=2e-06 sb=2e-06
    MM27 (Y\#2310 YN\#25 VSS!\#9 VSS!\#9) nch w=6e-06 l=1e-06 as=0 \
        ad=1.8e-11 ps=0 pd=1.8e-05 sa=2e-06 sb=2e-06
    MM26 (Y\#2312 YN\#27 VSS!\#9 VSS!\#9) nch w=6e-06 l=1e-06 as=0 \
        ad=1.8e-11 ps=0 pd=1.8e-05 sa=2e-06 sb=2e-06
    MM22 (Y\#2312 YN\#29 VSS!\#2310 VSS!\#2310) nch w=6e-06 l=1e-06 as=0 \
        ad=1.8e-11 ps=0 pd=1.8e-05 sa=2e-06 sb=2e-06
    MM21 (Y\#6 YN\#31 VSS!\#2310 VSS!\#2310) nch w=6e-06 l=1e-06 as=0 \
        ad=1.8e-11 ps=0 pd=1.8e-05 sa=2e-06 sb=2e-06
    MX13_M0_unmatched (Y\#6 YN\#33 VSS!\#2311 VSS!\#2311) nch w=6e-06 \
        l=1e-06 as=1.8e-11 ad=0 ps=1.8e-05 pd=0 sa=2e-06 sb=2e-06
    MM2 (YN\#5 A\#6 VSS!\#2312 VSS!\#2312) nch w=6e-06 l=1e-06 as=0 \
        ad=1.5e-11 ps=0 pd=1.7e-05 sa=2e-06 sb=2e-06
    MM32 (YN\#4 A\#9 VSS!\#7 VSS!\#7) nch w=6e-06 l=1e-06 as=0 ad=1.8e-11 \
        ps=0 pd=1.8e-05 sa=2e-06 sb=2e-06
    MM29 (YN\#4 A\#7 VSS!\#2312 VSS!\#2312) nch w=6e-06 l=1e-06 as=0 \
        ad=1.8e-11 ps=0 pd=1.8e-05 sa=2e-06 sb=2e-06
ends BUFX27_analog_extracted
// End of subcircuit definition.

// Library name: KISTA_SOI_STDLIB2
// Cell name: BUFX32
// View name: analog_extracted
subckt BUFX32_analog_extracted A Y
    Rc59 (VDD!\#1 VDD!\#2) resistor r=1.4962
    Rc45 (VDD!\#2 VDD!\#2316) resistor r=2.9108
    Rd49 (YN\#2314 YN\#2315) resistor r=1936.0317
    Rs1 (3 VSS!) resistor r=50
    Rd25 (A\#2 A\#3) resistor r=1336.0317
    Rd42 (A\#3 A\#4) resistor r=258.7097
    Rc8 (A\#4 A\#2313) resistor r=1327.5659
    Rd43 (A\#5 A\#2315) resistor r=1327.5659
    Rc7 (A\#4 A\#5) resistor r=292.3445
    Rd26 (A\#5 A\#6) resistor r=292.3445
    Rc9 (A\#6 A\#2317) resistor r=1327.5659
    Rd45 (A\#7 A\#2319) resistor r=1327.5659
    Rc3 (A\#6 A\#7) resistor r=292.3445
    Rd27 (A\#7 A\#8) resistor r=292.3445
    Rc11 (A\#8 A\#21) resistor r=1327.5659
    Rd47 (A\#9 A\#23) resistor r=1327.5659
    Rc4 (A\#8 A\#9) resistor r=292.3445
    Rd28 (A\#9 A\#2310) resistor r=292.3445
    Rc6 (A\#2310 A\#25) resistor r=1327.5659
    Rc25 (Y\#1 Y\#3) resistor r=1.8435
    Rd68 (YN\#3 YN\#2310) resistor r=1.668
    Rc10 (A\#5 A\#2314) resistor r=1327.5659
    Rd46 (A\#6 A\#2316) resistor r=1327.5659
    Rd44 (A\#4 A\#2312) resistor r=1327.5659
    Rc2 (A\#3 A\#2311) resistor r=1336.0317
    Rc88 (YN\#2 YN\#8) resistor r=1.668
    Rd6 (VDD!\#2310 VDD!\#23) resistor r=1.4224
    Rc74 (YN\#2 YN\#3) resistor r=0.186
    Rc1 (VDD!\#2310 VDD!\#24) resistor r=2.9108
    Rc36 (VDD!\#24 VDD!\#2312) resistor r=2.9108
    Rd22 (VDD!\#2310 VDD!\#2312) resistor r=135.1m
    Rd7 (VDD!\#2312 VDD!\#26) resistor r=2.9037
    Rc22 (VDD!\#2312 VDD!\#25) resistor r=1.4224
    Rd21 (VDD! VDD!\#2312) resistor r=135.4m
    Rc37 (YN\#4 YN\#2312) resistor r=1.668
    Rc12 (A\#7 A\#2318) resistor r=1327.5659
    Rd48 (A\#8 A\#20) resistor r=1327.5659
    Rc13 (A\#9 A\#22) resistor r=1327.5659
    Rd67 (YN\#3 YN\#4) resistor r=0.186
    Rc50 (YN\#3 YN\#9) resistor r=2.668
    Rd3 (VDD! VDD!\#2314) resistor r=1.4222
    Rc14 (VDD! VDD!\#26) resistor r=2.9182
    Rc44 (VSS! VSS!\#26) resistor r=5.3242
    Rd11 (VSS!\#2310 VSS!\#23) resistor r=2.6224
    Rd37 (YN\#2 YN\#7) resistor r=2.668
    Rd65 (YN YN\#2) resistor r=5.193
    Rc57 (VSS!\#2310 VSS!\#24) resistor r=5.3108
    Rc43 (VSS!\#24 VSS!\#2312) resistor r=5.3108
    Rd2 (VSS!\#2310 VSS!\#2312) resistor r=133.7m
    Rd14 (VSS! VSS!\#2312) resistor r=0.134
    Rd13 (VSS!\#2312 VSS!\#26) resistor r=5.2977
    Rc58 (VSS!\#2312 VSS!\#25) resistor r=2.6224
    Rd38 (YN\#4 YN\#2311) resistor r=2.668
    Rc87 (YN\#29 YN\#58) resistor r=727.5659
    Rd63 (YN\#29 YN\#59) resistor r=1927.5659
    Rc42 (VSS!\#22 VSS!\#2310) resistor r=3.9531
    Rd12 (VSS!\#8 VSS!\#2310) resistor r=99.5m
    Rd10 (VSS!\#8 VSS!\#21) resistor r=2.6224
    Rc56 (VSS!\#8 VSS!\#22) resistor r=7.9861
    Rc23 (Y Y\#9) resistor r=2.775
    Rc75 (YN\#30 YN) resistor r=114.0987
    Rd66 (YN\#30 YN\#60) resistor r=727.5659
    Rd36 (YN\#29 YN\#30) resistor r=292.3445
    Rc73 (YN\#30 YN\#61) resistor r=1927.5659
    Rc72 (YN\#28 YN\#29) resistor r=292.3445
    Rd64 (YN\#28 YN\#56) resistor r=727.5659
    Rd24 (Y Y\#23) resistor r=1.575
    Rc19 (Y Y\#8) resistor r=0.193
    Rc86 (YN\#28 YN\#57) resistor r=1927.5659
    Rd35 (YN\#27 YN\#28) resistor r=292.3445
    Rd61 (YN\#27 YN\#55) resistor r=1927.5659
    Rc34 (Y\#8 Y\#21) resistor r=2.768
    Rc41 (VSS!\#20 VSS!\#8) resistor r=5.3108
    Rd1 (VSS!\#6 VSS!\#8) resistor r=133.7m
    Rc55 (VSS!\#6 VSS!\#20) resistor r=5.3108
    Rc71 (YN\#27 YN\#54) resistor r=727.5659
    Rc85 (YN\#26 YN\#27) resistor r=292.3445
    Rd62 (YN\#26 YN\#52) resistor r=727.5659
    Rc70 (YN\#26 YN\#53) resistor r=1927.5659
    Rd40 (VSS!\#6 VSS!\#2319) resistor r=2.6224
    Rc84 (YN\#25 YN\#50) resistor r=727.5659
    Rc32 (Y\#7 Y\#2319) resistor r=2.768
    Rd34 (YN\#25 YN\#26) resistor r=292.3445
    Rd59 (YN\#25 YN\#51) resistor r=1927.5659
    Rc69 (YN\#24 YN\#25) resistor r=292.3445
    Rd60 (YN\#24 YN\#48) resistor r=727.5659
    Rc83 (YN\#24 YN\#49) resistor r=1927.5659
    Rc21 (Y\#7 Y\#8) resistor r=0.186
    Rc35 (Y\#8 Y\#22) resistor r=1.568
    Rc40 (VSS!\#2318 VSS!\#6) resistor r=5.3108
    Rd41 (VSS!\#4 VSS!\#6) resistor r=133.7m
    Rc54 (VSS!\#4 VSS!\#2318) resistor r=5.3108
    Rd58 (YN\#22 YN\#44) resistor r=727.5659
    Rc67 (YN\#22 YN\#45) resistor r=1927.5659
    Rc68 (YN\#23 YN\#46) resistor r=727.5659
    Rc30 (Y\#6 Y\#2317) resistor r=2.768
    Rd33 (YN\#23 YN\#24) resistor r=292.3445
    Rd57 (YN\#23 YN\#47) resistor r=1927.5659
    Rc82 (YN\#22 YN\#23) resistor r=292.3445
    Rc18 (Y\#6 Y\#7) resistor r=0.186
    Rc33 (Y\#7 Y\#20) resistor r=1.568
    Rd69 (VSS! VSS!\#2314) resistor r=2.6222
    Rc5 (A\#2310 A) resistor r=119.1987
    Rd50 (A\#2310 A\#24) resistor r=1327.5659
    Rd70 (YN\#4 YN\#6) resistor r=3.1213
    Rc51 (YN\#4 YN\#2313) resistor r=1.9537
    Rc52 (YN\#2313 YN\#6) resistor r=30.2634
    Rd53 (YN\#2319 YN\#39) resistor r=1927.5659
    Rc39 (VSS!\#2316 VSS!\#4) resistor r=5.3108
    Rc65 (YN\#2319 YN\#38) resistor r=727.5659
    Rd54 (YN\#2318 YN\#36) resistor r=727.5659
    Rc64 (YN\#2318 YN\#37) resistor r=1927.5659
    Rc79 (YN\#2318 YN\#2319) resistor r=292.3445
    Rd30 (YN\#2317 YN\#2318) resistor r=292.3445
    Rd51 (YN\#2317 YN\#35) resistor r=1927.5659
    Rc60 (VDD!\#2316 VDD!\#4) resistor r=2.9108
    Rc53 (VSS!\#2 VSS!\#2316) resistor r=5.3108
    Rd23 (Y\#1 Y\#2310) resistor r=29.6259
    Rc76 (YN\#2315 YN\#31) resistor r=736.0318
    Rd29 (YN\#2315 YN\#2316) resistor r=258.7097
    Rc77 (YN\#2316 YN\#2317) resistor r=292.3445
    Rc78 (YN\#2317 YN\#34) resistor r=727.5659
    Rd16 (VDD!\#2 VDD!\#2315) resistor r=1.4224
    Rd15 (VDD!\#2 VDD!\#4) resistor r=135.1m
    Rd72 (VSS!\#2 VSS!\#4) resistor r=133.7m
    Rd71 (VSS!\#4 VSS!\#2317) resistor r=2.6224
    Rd32 (YN\#21 YN\#22) resistor r=292.3445
    Rc17 (Y\#5 Y\#6) resistor r=0.186
    Rc31 (Y\#6 Y\#2318) resistor r=1.568
    Rc27 (Y\#4 Y\#2314) resistor r=1.568
    Rd31 (YN\#2319 YN\#20) resistor r=292.3445
    Rd19 (VDD!\#8 VDD!\#2310) resistor r=100.2m
    Rc48 (VDD!\#22 VDD!\#2310) resistor r=2.1591
    Rc63 (YN\#2316 YN\#33) resistor r=1927.5659
    Rc38 (VSS!\#1 VSS!\#2) resistor r=2.6962
    Rd39 (VSS!\#2 VSS!\#2315) resistor r=2.6224
    Rd52 (YN\#2316 YN\#32) resistor r=727.5659
    Rd9 (Y\#2310 Y\#3) resistor r=3.2498
    Rd8 (Y\#3 Y\#2311) resistor r=2.768
    Rc24 (Y\#3 Y\#2312) resistor r=1.568
    Rc15 (Y\#3 Y\#4) resistor r=0.186
    Rd56 (YN\#20 YN\#40) resistor r=727.5659
    Rc66 (YN\#20 YN\#21) resistor r=292.3445
    Rc81 (YN\#21 YN\#42) resistor r=727.5659
    Rc26 (Y\#4 Y\#2313) resistor r=2.768
    Rc28 (Y\#5 Y\#2315) resistor r=2.768
    Rc16 (Y\#4 Y\#5) resistor r=0.186
    Rc29 (Y\#5 Y\#2316) resistor r=1.568
    Rd55 (YN\#21 YN\#43) resistor r=1927.5659
    Rc46 (VDD!\#4 VDD!\#2318) resistor r=2.9108
    Rd4 (VDD!\#4 VDD!\#2317) resistor r=1.4224
    Rd18 (VDD!\#4 VDD!\#6) resistor r=135.1m
    Rc61 (VDD!\#2318 VDD!\#6) resistor r=2.9108
    Rc80 (YN\#20 YN\#41) resistor r=1927.5659
    Rd17 (VDD!\#6 VDD!\#2319) resistor r=1.4224
    Rc47 (VDD!\#6 VDD!\#20) resistor r=2.9108
    Rd5 (VDD!\#6 VDD!\#8) resistor r=135.1m
    Rc49 (VDD!\#20 VDD!\#8) resistor r=2.9108
    Rd20 (VDD!\#8 VDD!\#21) resistor r=1.4224
    Rc62 (VDD!\#8 VDD!\#22) resistor r=4.3619
    C39 (YN\#2314 VSS!) capacitor c=1.08754e-18
    C110 (Y\#1 VDD!\#1) capacitor c=196.338a
    C118 (VDD!\#1 YN\#2314) capacitor c=351.377a
    C139 (VDD!\#1 6) capacitor c=1.90545e-15
    C200 (Y\#1 YN\#2314) capacitor c=411.887a
    C251 (YN\#2314 3) capacitor c=1.85673e-15
    C299 (YN\#2314 6) capacitor c=481.565a
    C83 (YN\#2315 VSS!) capacitor c=2.44243e-18
    C284 (YN\#2315 3) capacitor c=3.95354e-15
    C1 (VDD!\#2316 VSS!) capacitor c=44.9422a
    C2 (VDD!\#24 VSS!) capacitor c=48.2932a
    C3 (VDD!\#25 VSS!) capacitor c=48.4016a
    C4 (VDD!\#26 VSS!) capacitor c=48.2004a
    C5 (A\#2 VSS!) capacitor c=18.5978a
    C167 (A\#2 3) capacitor c=1.26764e-15
    C6 (A\#2313 VSS!) capacitor c=6.64132e-18
    C101 (VDD!\#24 A\#2313) capacitor c=328.82a
    C168 (A\#2313 3) capacitor c=1.28403e-15
    C7 (A\#2315 VSS!) capacitor c=7.74197e-18
    C102 (VDD!\#24 A\#2315) capacitor c=328.82a
    C169 (A\#2315 3) capacitor c=1.25588e-15
    C8 (A\#2317 VSS!) capacitor c=7.78156e-18
    C103 (VDD!\#25 A\#2317) capacitor c=328.82a
    C170 (A\#2317 3) capacitor c=1.28404e-15
    C9 (A\#2319 VSS!) capacitor c=8.34298e-18
    C104 (VDD!\#25 A\#2319) capacitor c=328.82a
    C171 (A\#2319 3) capacitor c=1.25611e-15
    C10 (A\#21 VSS!) capacitor c=7.974e-18
    C105 (VDD!\#26 A\#21) capacitor c=328.82a
    C172 (A\#21 3) capacitor c=1.28344e-15
    C11 (A\#23 VSS!) capacitor c=6.93555e-18
    C106 (VDD!\#26 A\#23) capacitor c=328.82a
    C173 (A\#23 3) capacitor c=1.25603e-15
    C12 (A\#25 VSS!) capacitor c=8.13788e-18
    C174 (A\#25 3) capacitor c=1.23855e-15
    C22 (A\#3 VSS!) capacitor c=10.0339a
    C183 (A\#3 3) capacitor c=3.93039e-15
    C23 (A\#4 VSS!) capacitor c=11.5857a
    C184 (A\#4 3) capacitor c=4.63908e-15
    C24 (A\#5 VSS!) capacitor c=9.14189e-18
    C185 (A\#5 3) capacitor c=4.5904e-15
    C25 (A\#6 VSS!) capacitor c=12.9229a
    C186 (A\#6 3) capacitor c=4.63908e-15
    C26 (A\#7 VSS!) capacitor c=13.1861a
    C187 (A\#7 3) capacitor c=4.59075e-15
    C27 (A\#8 VSS!) capacitor c=9.5907e-18
    C188 (A\#8 3) capacitor c=4.6387e-15
    C28 (A\#9 VSS!) capacitor c=10.983a
    C189 (A\#9 3) capacitor c=4.63719e-15
    C29 (A\#2310 VSS!) capacitor c=1.99666e-19
    C190 (A\#2310 3) capacitor c=239.767a
    C37 (Y\#3 VSS!) capacitor c=179.1a
    C234 (YN\#2315 Y\#3) capacitor c=726.258a
    C249 (Y\#3 3) capacitor c=26.3948f
    C40 (YN\#33 VSS!) capacitor c=5.96132e-19
    C201 (Y\#1 YN\#33) capacitor c=419.723a
    C252 (YN\#33 3) capacitor c=1.97906e-15
    C300 (YN\#33 6) capacitor c=510.912a
    C41 (YN\#35 VSS!) capacitor c=8.76898e-18
    C253 (YN\#35 3) capacitor c=1.9317e-15
    C301 (YN\#35 6) capacitor c=510.794a
    C42 (YN\#37 VSS!) capacitor c=7.25243e-18
    C121 (VDD!\#2316 YN\#37) capacitor c=326.539a
    C254 (YN\#37 3) capacitor c=1.97923e-15
    C302 (YN\#37 6) capacitor c=510.942a
    C43 (YN\#39 VSS!) capacitor c=2.98145e-18
    C122 (VDD!\#2316 YN\#39) capacitor c=332.106a
    C255 (YN\#39 3) capacitor c=1.9327e-15
    C303 (YN\#39 6) capacitor c=510.942a
    C44 (YN\#41 VSS!) capacitor c=8.54774e-18
    C256 (YN\#41 3) capacitor c=1.97923e-15
    C304 (YN\#41 6) capacitor c=510.942a
    C45 (YN\#43 VSS!) capacitor c=1.39111e-18
    C257 (YN\#43 3) capacitor c=1.9327e-15
    C305 (YN\#43 6) capacitor c=510.942a
    C46 (YN\#45 VSS!) capacitor c=2.98145e-18
    C258 (YN\#45 3) capacitor c=1.97923e-15
    C306 (YN\#45 6) capacitor c=510.942a
    C47 (YN\#47 VSS!) capacitor c=1.39111e-18
    C259 (YN\#47 3) capacitor c=1.9327e-15
    C307 (YN\#47 6) capacitor c=510.942a
    C48 (YN\#49 VSS!) capacitor c=2.98145e-18
    C260 (YN\#49 3) capacitor c=1.97923e-15
    C308 (YN\#49 6) capacitor c=510.942a
    C49 (YN\#51 VSS!) capacitor c=1.39111e-18
    C261 (YN\#51 3) capacitor c=1.9327e-15
    C309 (YN\#51 6) capacitor c=510.942a
    C50 (YN\#53 VSS!) capacitor c=1.39111e-18
    C262 (YN\#53 3) capacitor c=1.97923e-15
    C310 (YN\#53 6) capacitor c=510.942a
    C51 (YN\#55 VSS!) capacitor c=1.4055e-18
    C263 (YN\#55 3) capacitor c=1.9327e-15
    C311 (YN\#55 6) capacitor c=510.942a
    C52 (YN\#57 VSS!) capacitor c=1.38031e-18
    C264 (YN\#57 3) capacitor c=1.97886e-15
    C312 (YN\#57 6) capacitor c=510.884a
    C53 (YN\#59 VSS!) capacitor c=6.13689e-18
    C265 (YN\#59 3) capacitor c=1.93275e-15
    C313 (YN\#59 6) capacitor c=511.067a
    C54 (YN\#61 VSS!) capacitor c=1.1809e-18
    C266 (YN\#61 3) capacitor c=2.00159e-15
    C314 (YN\#61 6) capacitor c=524.746a
    C250 (Y\#23 6) capacitor c=1.23992e-15
    C228 (Y\#23 YN\#59) capacitor c=419.452a
    C229 (Y\#23 YN\#61) capacitor c=415.2a
    C72 (YN\#8 VSS!) capacitor c=5.60575e-18
    C134 (VDD!\#24 YN\#8) capacitor c=345.252a
    C141 (YN\#8 A\#2) capacitor c=347.332a
    C142 (YN\#8 A\#2313) capacitor c=352.496a
    C232 (YN\#8 Y\#23) capacitor c=5.17013e-18
    C192 (A\#2313 8) capacitor c=511.067a
    C99 (8 VSS!) capacitor c=2.866e-18
    C191 (A\#2 8) capacitor c=496.373a
    C193 (A\#2315 8) capacitor c=510.884a
    C194 (A\#2317 8) capacitor c=510.942a
    C195 (A\#2319 8) capacitor c=510.942a
    C196 (A\#21 8) capacitor c=510.794a
    C197 (A\#23 8) capacitor c=510.912a
    C198 (A\#25 8) capacitor c=509.939a
    C315 (YN\#8 8) capacitor c=631.387a
    C140 (VDD!\#2314 8) capacitor c=1.22952e-15
    C108 (VDD!\#2314 A\#25) capacitor c=345.416a
    C109 (A\#2310 VDD!\#2314) capacitor c=3.82381e-19
    C74 (YN\#2310 VSS!) capacitor c=11.4211a
    C135 (YN\#2310 VDD!\#24) capacitor c=345.252a
    C145 (YN\#2310 A\#2315) capacitor c=351.126a
    C146 (YN\#2310 A\#2317) capacitor c=350.543a
    C159 (YN\#3 A\#5) capacitor c=1.21776e-15
    C160 (YN\#3 A\#6) capacitor c=1.21394e-15
    C177 (A\#2314 3) capacitor c=1.76048e-15
    C178 (A\#2316 3) capacitor c=1.78556e-15
    C15 (VSS!\#24 A\#2314) capacitor c=233.147a
    C14 (VSS!\#24 A\#2312) capacitor c=231.921a
    C176 (A\#2312 3) capacitor c=1.78572e-15
    C158 (YN\#2 A\#4) capacitor c=1.21632e-15
    C157 (YN\#2 A\#3) capacitor c=1.16015e-15
    C175 (A\#2311 3) capacitor c=1.68513e-15
    C100 (VDD!\#23 A\#2) capacitor c=343.735a
    C138 (VDD!\#2310 3) capacitor c=60.4834f
    C149 (YN\#2312 A\#2319) capacitor c=350.543a
    C76 (YN\#2312 VSS!) capacitor c=11.4217a
    C136 (VDD!\#26 YN\#2312) capacitor c=345.252a
    C150 (YN\#2312 A\#21) capacitor c=352.029a
    C81 (YN\#4 VSS!) capacitor c=75.8362a
    C162 (YN\#4 A\#7) capacitor c=1.21331e-15
    C163 (YN\#4 A\#8) capacitor c=1.21798e-15
    C164 (YN\#4 A\#9) capacitor c=1.22191e-15
    C165 (YN\#4 A\#2310) capacitor c=33.9257a
    C179 (A\#2318 3) capacitor c=1.76074e-15
    C180 (A\#20 3) capacitor c=1.78489e-15
    C181 (A\#22 3) capacitor c=1.76061e-15
    C283 (YN\#4 3) capacitor c=19.4105f
    C75 (YN\#9 VSS!\#24) capacitor c=211.738a
    C147 (YN\#9 A\#2314) capacitor c=246.843a
    C148 (YN\#9 A\#2316) capacitor c=249.464a
    C16 (VSS!\#25 A\#2316) capacitor c=232.95a
    C17 (VSS!\#25 A\#2318) capacitor c=233.455a
    C82 (YN\#4 VSS!\#25) capacitor c=26.0374a
    C13 (VSS!\#23 A\#2311) capacitor c=247.195a
    C80 (YN\#2 VSS!\#23) capacitor c=13.0231a
    C18 (VSS!\#26 A\#20) capacitor c=233.74a
    C19 (VSS!\#26 A\#22) capacitor c=232.165a
    C73 (VSS!\#24 YN\#7) capacitor c=236.702a
    C143 (YN\#7 A\#2311) capacitor c=254.328a
    C98 (VSS!\#2310 3) capacitor c=62.7732f
    C144 (YN\#7 A\#2312) capacitor c=251.25a
    C233 (YN\#7 Y\#9) capacitor c=1.72361e-18
    C151 (YN\#2311 A\#2318) capacitor c=246.552a
    C77 (VSS!\#26 YN\#2311) capacitor c=237.776a
    C152 (YN\#2311 A\#20) capacitor c=250.207a
    C36 (Y\#9 VSS!\#21) capacitor c=291.948a
    C68 (VSS!\#21 YN\#56) capacitor c=230.134a
    C280 (YN\#56 3) capacitor c=1.06796e-15
    C69 (VSS!\#21 YN\#58) capacitor c=229.324a
    C230 (Y\#9 YN\#58) capacitor c=182.711a
    C281 (YN\#58 3) capacitor c=1.06207e-15
    C97 (YN\#29 VSS!\#21) capacitor c=8.58473e-18
    C298 (YN\#29 3) capacitor c=4.45725e-15
    C70 (VSS!\#22 YN) capacitor c=49.9854a
    C71 (VSS!\#22 YN\#60) capacitor c=245.82a
    C231 (Y\#9 YN\#60) capacitor c=180.052a
    C199 (YN Y) capacitor c=723.91a
    C248 (YN\#29 Y) capacitor c=1.23222e-15
    C282 (YN\#60 3) capacitor c=1.10811e-15
    C96 (YN\#28 VSS!\#21) capacitor c=10.328a
    C227 (Y\#21 YN\#56) capacitor c=182.01a
    C297 (YN\#28 3) capacitor c=4.54319e-15
    C247 (YN\#28 Y\#8) capacitor c=1.27784e-15
    C246 (YN\#27 Y\#8) capacitor c=1.27383e-15
    C296 (YN\#27 3) capacitor c=4.49503e-15
    C35 (Y\#21 VSS!\#20) capacitor c=209.854a
    C95 (YN\#27 VSS!\#20) capacitor c=10.3568a
    C66 (VSS!\#20 YN\#52) capacitor c=230.145a
    C278 (YN\#52 3) capacitor c=1.06811e-15
    C67 (VSS!\#20 YN\#54) capacitor c=230.159a
    C226 (Y\#21 YN\#54) capacitor c=181.719a
    C279 (YN\#54 3) capacitor c=1.0619e-15
    C94 (YN\#26 VSS!\#20) capacitor c=10.328a
    C223 (Y\#2319 YN\#52) capacitor c=181.719a
    C295 (YN\#26 3) capacitor c=4.54342e-15
    C34 (Y\#2319 VSS!\#2319) capacitor c=209.854a
    C64 (VSS!\#2319 YN\#48) capacitor c=230.145a
    C276 (YN\#48 3) capacitor c=1.06811e-15
    C65 (VSS!\#2319 YN\#50) capacitor c=230.145a
    C222 (Y\#2319 YN\#50) capacitor c=181.719a
    C277 (YN\#50 3) capacitor c=1.0619e-15
    C93 (YN\#25 VSS!\#2319) capacitor c=10.3338a
    C244 (YN\#25 Y\#7) capacitor c=1.27383e-15
    C245 (YN\#26 Y\#7) capacitor c=1.27737e-15
    C294 (YN\#25 3) capacitor c=4.49503e-15
    C92 (YN\#24 VSS!\#2319) capacitor c=10.328a
    C219 (Y\#2317 YN\#48) capacitor c=181.719a
    C293 (YN\#24 3) capacitor c=4.54342e-15
    C224 (Y\#22 YN\#55) capacitor c=418.094a
    C225 (Y\#22 YN\#57) capacitor c=418.94a
    C33 (Y\#2317 VSS!\#2318) capacitor c=209.854a
    C38 (VSS!\#4 Y\#2315) capacitor c=106.601a
    C62 (VSS!\#2318 YN\#44) capacitor c=230.145a
    C215 (Y\#2315 YN\#44) capacitor c=181.719a
    C274 (YN\#44 3) capacitor c=1.06811e-15
    C90 (YN\#22 VSS!\#2318) capacitor c=10.328a
    C291 (YN\#22 3) capacitor c=4.54342e-15
    C63 (VSS!\#2318 YN\#46) capacitor c=230.145a
    C218 (Y\#2317 YN\#46) capacitor c=181.719a
    C275 (YN\#46 3) capacitor c=1.0619e-15
    C91 (YN\#23 VSS!\#2318) capacitor c=10.3338a
    C242 (YN\#23 Y\#6) capacitor c=1.27383e-15
    C243 (YN\#24 Y\#6) capacitor c=1.27737e-15
    C292 (YN\#23 3) capacitor c=4.49503e-15
    C220 (Y\#20 YN\#51) capacitor c=418.065a
    C221 (Y\#20 YN\#53) capacitor c=418.065a
    C78 (YN\#2313 VSS!) capacitor c=6.89933e-18
    C137 (YN\#2313 VDD!\#26) capacitor c=345.252a
    C153 (YN\#2313 A\#23) capacitor c=352.752a
    C154 (YN\#2313 A\#25) capacitor c=345.178a
    C107 (VDD!\#2314 A) capacitor c=8.55475e-18
    C20 (VSS!\#2314 A) capacitor c=23.8177a
    C161 (YN\#4 A) capacitor c=815.636a
    C166 (3 A) capacitor c=6.06015e-15
    C21 (VSS!\#2314 A\#24) capacitor c=244.156a
    C79 (YN\#6 VSS!\#26) capacitor c=210.945a
    C155 (YN\#6 A\#22) capacitor c=248.54a
    C156 (YN\#6 A\#24) capacitor c=243.524a
    C182 (A\#24 3) capacitor c=1.73798e-15
    C112 (Y\#2314 VDD!\#2316) capacitor c=637.204a
    C208 (Y\#2314 YN\#39) capacitor c=416.475a
    C209 (Y\#2314 YN\#41) capacitor c=416.475a
    C288 (YN\#2319 3) capacitor c=4.49503e-15
    C87 (YN\#2319 VSS!\#2316) capacitor c=10.3338a
    C32 (Y\#2313 VSS!\#2316) capacitor c=313.108a
    C58 (VSS!\#2316 YN\#36) capacitor c=230.44a
    C270 (YN\#36 3) capacitor c=1.06811e-15
    C59 (VSS!\#2316 YN\#38) capacitor c=230.145a
    C210 (Y\#2313 YN\#38) capacitor c=181.719a
    C271 (YN\#38 3) capacitor c=1.0619e-15
    C86 (YN\#2318 VSS!\#2316) capacitor c=10.9771a
    C237 (YN\#2318 Y\#3) capacitor c=1.27737e-15
    C287 (YN\#2318 3) capacitor c=4.54342e-15
    C236 (YN\#2317 Y\#3) capacitor c=1.2758e-15
    C286 (YN\#2317 3) capacitor c=4.49421e-15
    C85 (YN\#2317 VSS!\#2315) capacitor c=10.3338a
    C205 (Y\#2312 YN\#37) capacitor c=418.655a
    C207 (Y\#2311 YN\#36) capacitor c=181.719a
    C241 (YN\#22 Y\#5) capacitor c=1.27737e-15
    C238 (YN\#2319 Y\#4) capacitor c=1.27383e-15
    C128 (VDD!\#2319 YN\#51) capacitor c=332.106a
    C129 (VDD!\#20 YN\#53) capacitor c=332.106a
    C130 (VDD!\#20 YN\#55) capacitor c=332.106a
    C131 (VDD!\#21 YN\#57) capacitor c=332.106a
    C132 (VDD!\#21 YN\#59) capacitor c=326.539a
    C133 (VDD!\#22 YN\#61) capacitor c=355.516a
    C119 (VDD!\#2315 YN\#33) capacitor c=332.879a
    C30 (Y\#2310 VSS!\#1) capacitor c=132.417a
    C55 (VSS!\#1 YN\#31) capacitor c=243.286a
    C202 (Y\#2310 YN\#31) capacitor c=178.958a
    C84 (YN\#2316 VSS!\#2315) capacitor c=8.57901e-18
    C31 (Y\#2311 VSS!\#2315) capacitor c=209.854a
    C56 (VSS!\#2315 YN\#32) capacitor c=230.022a
    C203 (Y\#2310 YN\#32) capacitor c=182.823a
    C268 (YN\#32 3) capacitor c=1.06798e-15
    C235 (YN\#2316 Y\#3) capacitor c=1.28081e-15
    C267 (YN\#31 3) capacitor c=1.00015e-15
    C285 (YN\#2316 3) capacitor c=4.54342e-15
    C57 (VSS!\#2315 YN\#34) capacitor c=230.366a
    C206 (Y\#2311 YN\#34) capacitor c=182.462a
    C269 (YN\#34 3) capacitor c=1.06153e-15
    C111 (Y\#2312 VDD!\#2315) capacitor c=345.252a
    C120 (VDD!\#2315 YN\#35) capacitor c=326.539a
    C204 (Y\#2312 YN\#35) capacitor c=418.671a
    C116 (VDD!\#4 Y\#2316) capacitor c=53.3005a
    C60 (VSS!\#2317 YN\#40) capacitor c=230.145a
    C272 (YN\#40 3) capacitor c=1.06811e-15
    C61 (VSS!\#2317 YN\#42) capacitor c=230.145a
    C273 (YN\#42 3) capacitor c=1.0619e-15
    C88 (YN\#20 VSS!\#2317) capacitor c=10.328a
    C239 (YN\#20 Y\#4) capacitor c=1.27737e-15
    C289 (YN\#20 3) capacitor c=4.54342e-15
    C290 (YN\#21 3) capacitor c=4.49503e-15
    C89 (YN\#21 VSS!\#2317) capacitor c=10.3338a
    C211 (Y\#2313 YN\#40) capacitor c=181.719a
    C214 (Y\#2315 YN\#42) capacitor c=181.719a
    C240 (YN\#21 Y\#5) capacitor c=1.27383e-15
    C212 (Y\#2316 YN\#43) capacitor c=418.065a
    C113 (Y\#2318 VDD!\#2318) capacitor c=345.252a
    C124 (VDD!\#2317 YN\#43) capacitor c=332.106a
    C123 (VDD!\#2317 YN\#41) capacitor c=326.539a
    C125 (VDD!\#2318 YN\#45) capacitor c=332.106a
    C213 (Y\#2316 YN\#45) capacitor c=416.475a
    C126 (VDD!\#2318 YN\#47) capacitor c=332.106a
    C216 (Y\#2318 YN\#47) capacitor c=418.065a
    C217 (Y\#2318 YN\#49) capacitor c=416.475a
    C127 (VDD!\#2319 YN\#49) capacitor c=332.106a
    C114 (Y\#20 VDD!\#2319) capacitor c=637.204a
    C117 (VDD!\#8 Y\#22) capacitor c=53.3005a
    C115 (Y\#23 VDD!\#21) capacitor c=491.228a
    MX16_X1_M0_unmatched (Y\#1 YN\#2314 VDD!\#1 VDD!\#1) pch w=8e-06 \
        l=1e-06 as=0 ad=2.4e-11 ps=0 pd=2.2e-05 sa=2e-06 sb=2e-06
    MX9_X0_M0_unmatched (YN\#8 A\#2313 VDD!\#24 VDD!\#24) pch w=8e-06 \
        l=1e-06 as=0 ad=2.4e-11 ps=0 pd=2.2e-05 sa=2e-06 sb=2e-06
    MX8_X1_M0_unmatched (YN\#2310 A\#2315 VDD!\#24 VDD!\#24) pch w=8e-06 \
        l=1e-06 as=0 ad=2.4e-11 ps=0 pd=2.2e-05 sa=2e-06 sb=2e-06
    MX8_X0_M0_unmatched (YN\#2310 A\#2317 VDD!\#25 VDD!\#25) pch w=8e-06 \
        l=1e-06 as=0 ad=2.4e-11 ps=0 pd=2.2e-05 sa=2e-06 sb=2e-06
    MX9_X1_M0_unmatched (YN\#8 A\#2 VDD!\#23 VDD!\#23) pch w=8e-06 l=1e-06 \
        as=0 ad=2.4e-11 ps=0 pd=2.2e-05 sa=2e-06 sb=2e-06
    MX7_X1_M0_unmatched (YN\#2312 A\#2319 VDD!\#25 VDD!\#25) pch w=8e-06 \
        l=1e-06 as=0 ad=2.4e-11 ps=0 pd=2.2e-05 sa=2e-06 sb=2e-06
    MX7_X0_M0_unmatched (YN\#2312 A\#21 VDD!\#26 VDD!\#26) pch w=8e-06 \
        l=1e-06 as=0 ad=2.4e-11 ps=0 pd=2.2e-05 sa=2e-06 sb=2e-06
    MX6_X1_M0_unmatched (YN\#2313 A\#23 VDD!\#26 VDD!\#26) pch w=8e-06 \
        l=1e-06 as=0 ad=2.4e-11 ps=0 pd=2.2e-05 sa=2e-06 sb=2e-06
    MX6_X0_M0_unmatched (YN\#2313 A\#25 VDD!\#2314 VDD!\#2314) pch w=8e-06 \
        l=1e-06 as=0 ad=2.4e-11 ps=0 pd=2.2e-05 sa=2e-06 sb=2e-06
    MX14_X1_M0_unmatched (Y\#2314 YN\#39 VDD!\#2316 VDD!\#2316) pch \
        w=8e-06 l=1e-06 as=0 ad=2.4e-11 ps=0 pd=2.2e-05 sa=2e-06 sb=2e-06
    MX15_X0_M0_unmatched (Y\#2312 YN\#37 VDD!\#2316 VDD!\#2316) pch \
        w=8e-06 l=1e-06 as=0 ad=2.4e-11 ps=0 pd=2.2e-05 sa=2e-06 sb=2e-06
    MX16_X0_M0_unmatched (Y\#1 YN\#33 VDD!\#2315 VDD!\#2315) pch w=8e-06 \
        l=1e-06 as=0 ad=2.4e-11 ps=0 pd=2.2e-05 sa=2e-06 sb=2e-06
    MX14_X0_M0_unmatched (Y\#2314 YN\#41 VDD!\#2317 VDD!\#2317) pch \
        w=8e-06 l=1e-06 as=0 ad=2.4e-11 ps=0 pd=2.2e-05 sa=2e-06 sb=2e-06
    MX11_X1_M0_unmatched (Y\#20 YN\#51 VDD!\#2319 VDD!\#2319) pch w=8e-06 \
        l=1e-06 as=0 ad=2.4e-11 ps=0 pd=2.2e-05 sa=2e-06 sb=2e-06
    MX11_X0_M0_unmatched (Y\#20 YN\#53 VDD!\#20 VDD!\#20) pch w=8e-06 \
        l=1e-06 as=0 ad=2.4e-11 ps=0 pd=2.2e-05 sa=2e-06 sb=2e-06
    MX10_X1_M0_unmatched (Y\#22 YN\#55 VDD!\#20 VDD!\#20) pch w=8e-06 \
        l=1e-06 as=0 ad=2.4e-11 ps=0 pd=2.2e-05 sa=2e-06 sb=2e-06
    MX10_X0_M0_unmatched (Y\#22 YN\#57 VDD!\#21 VDD!\#21) pch w=8e-06 \
        l=1e-06 as=0 ad=2.4e-11 ps=0 pd=2.2e-05 sa=2e-06 sb=2e-06
    MX4_M0_unmatched (Y\#23 YN\#59 VDD!\#21 VDD!\#21) pch w=8e-06 l=1e-06 \
        as=0 ad=2.4e-11 ps=0 pd=2.2e-05 sa=2e-06 sb=2e-06
    MX3_M0_unmatched (Y\#23 YN\#61 VDD!\#22 VDD!\#22) pch w=8e-06 l=1e-06 \
        as=2.4e-11 ad=0 ps=2.2e-05 pd=0 sa=2e-06 sb=2e-06
    MX15_X1_M0_unmatched (Y\#2312 YN\#35 VDD!\#2315 VDD!\#2315) pch \
        w=8e-06 l=1e-06 as=0 ad=2.4e-11 ps=0 pd=2.2e-05 sa=2e-06 sb=2e-06
    MX13_X1_M0_unmatched (Y\#2316 YN\#43 VDD!\#2317 VDD!\#2317) pch \
        w=8e-06 l=1e-06 as=0 ad=2.4e-11 ps=0 pd=2.2e-05 sa=2e-06 sb=2e-06
    MX13_X0_M0_unmatched (Y\#2316 YN\#45 VDD!\#2318 VDD!\#2318) pch \
        w=8e-06 l=1e-06 as=0 ad=2.4e-11 ps=0 pd=2.2e-05 sa=2e-06 sb=2e-06
    MX12_X1_M0_unmatched (Y\#2318 YN\#47 VDD!\#2318 VDD!\#2318) pch \
        w=8e-06 l=1e-06 as=0 ad=2.4e-11 ps=0 pd=2.2e-05 sa=2e-06 sb=2e-06
    MX12_X0_M0_unmatched (Y\#2318 YN\#49 VDD!\#2319 VDD!\#2319) pch \
        w=8e-06 l=1e-06 as=0 ad=2.4e-11 ps=0 pd=2.2e-05 sa=2e-06 sb=2e-06
    MX19_X1_M0_unmatched (YN\#9 A\#2314 VSS!\#24 VSS!\#24) nch w=4e-06 \
        l=1e-06 as=0 ad=1.2e-11 ps=0 pd=1.4e-05 sa=2e-06 sb=2e-06
    MX19_X0_M0_unmatched (YN\#9 A\#2316 VSS!\#25 VSS!\#25) nch w=4e-06 \
        l=1e-06 as=0 ad=1.2e-11 ps=0 pd=1.4e-05 sa=2e-06 sb=2e-06
    MX20_X1_M0_unmatched (YN\#7 A\#2311 VSS!\#23 VSS!\#23) nch w=4e-06 \
        l=1e-06 as=0 ad=1.2e-11 ps=0 pd=1.4e-05 sa=2e-06 sb=2e-06
    MX20_X0_M0_unmatched (YN\#7 A\#2312 VSS!\#24 VSS!\#24) nch w=4e-06 \
        l=1e-06 as=0 ad=1.2e-11 ps=0 pd=1.4e-05 sa=2e-06 sb=2e-06
    MX18_X1_M0_unmatched (YN\#2311 A\#2318 VSS!\#25 VSS!\#25) nch w=4e-06 \
        l=1e-06 as=0 ad=1.2e-11 ps=0 pd=1.4e-05 sa=2e-06 sb=2e-06
    MX18_X0_M0_unmatched (YN\#2311 A\#20 VSS!\#26 VSS!\#26) nch w=4e-06 \
        l=1e-06 as=0 ad=1.2e-11 ps=0 pd=1.4e-05 sa=2e-06 sb=2e-06
    MX2_M0_unmatched (Y\#9 YN\#58 VSS!\#21 VSS!\#21) nch w=4e-06 l=1e-06 \
        as=0 ad=1.2e-11 ps=0 pd=1.4e-05 sa=2e-06 sb=2e-06
    MX5_M0_unmatched (Y\#9 YN\#60 VSS!\#22 VSS!\#22) nch w=4e-06 l=1e-06 \
        as=1.2e-11 ad=0 ps=1.4e-05 pd=0 sa=2e-06 sb=2e-06
    MX21_X0_M0_unmatched (Y\#21 YN\#56 VSS!\#21 VSS!\#21) nch w=4e-06 \
        l=1e-06 as=0 ad=1.2e-11 ps=0 pd=1.4e-05 sa=2e-06 sb=2e-06
    MX21_X1_M0_unmatched (Y\#21 YN\#54 VSS!\#20 VSS!\#20) nch w=4e-06 \
        l=1e-06 as=0 ad=1.2e-11 ps=0 pd=1.4e-05 sa=2e-06 sb=2e-06
    MX22_X0_M0_unmatched (Y\#2319 YN\#52 VSS!\#20 VSS!\#20) nch w=4e-06 \
        l=1e-06 as=0 ad=1.2e-11 ps=0 pd=1.4e-05 sa=2e-06 sb=2e-06
    MX22_X1_M0_unmatched (Y\#2319 YN\#50 VSS!\#2319 VSS!\#2319) nch \
        w=4e-06 l=1e-06 as=0 ad=1.2e-11 ps=0 pd=1.4e-05 sa=2e-06 sb=2e-06
    MX23_X0_M0_unmatched (Y\#2317 YN\#48 VSS!\#2319 VSS!\#2319) nch \
        w=4e-06 l=1e-06 as=0 ad=1.2e-11 ps=0 pd=1.4e-05 sa=2e-06 sb=2e-06
    MX24_X0_M0_unmatched (Y\#2315 YN\#44 VSS!\#2318 VSS!\#2318) nch \
        w=4e-06 l=1e-06 as=0 ad=1.2e-11 ps=0 pd=1.4e-05 sa=2e-06 sb=2e-06
    MX23_X1_M0_unmatched (Y\#2317 YN\#46 VSS!\#2318 VSS!\#2318) nch \
        w=4e-06 l=1e-06 as=0 ad=1.2e-11 ps=0 pd=1.4e-05 sa=2e-06 sb=2e-06
    MX17_X0_M0_unmatched (YN\#6 A\#24 VSS!\#2314 VSS!\#2314) nch w=4e-06 \
        l=1e-06 as=0 ad=1.2e-11 ps=0 pd=1.4e-05 sa=2e-06 sb=2e-06
    MX17_X1_M0_unmatched (YN\#6 A\#22 VSS!\#26 VSS!\#26) nch w=4e-06 \
        l=1e-06 as=0 ad=1.2e-11 ps=0 pd=1.4e-05 sa=2e-06 sb=2e-06
    MX25_X1_M0_unmatched (Y\#2313 YN\#38 VSS!\#2316 VSS!\#2316) nch \
        w=4e-06 l=1e-06 as=0 ad=1.2e-11 ps=0 pd=1.4e-05 sa=2e-06 sb=2e-06
    MX26_X0_M0_unmatched (Y\#2311 YN\#36 VSS!\#2316 VSS!\#2316) nch \
        w=4e-06 l=1e-06 as=0 ad=1.2e-11 ps=0 pd=1.4e-05 sa=2e-06 sb=2e-06
    MX27_X1_M0_unmatched (Y\#2310 YN\#31 VSS!\#1 VSS!\#1) nch w=4e-06 \
        l=1e-06 as=0 ad=1.2e-11 ps=0 pd=1.4e-05 sa=2e-06 sb=2e-06
    MX27_X0_M0_unmatched (Y\#2310 YN\#32 VSS!\#2315 VSS!\#2315) nch \
        w=4e-06 l=1e-06 as=0 ad=1.2e-11 ps=0 pd=1.4e-05 sa=2e-06 sb=2e-06
    MX26_X1_M0_unmatched (Y\#2311 YN\#34 VSS!\#2315 VSS!\#2315) nch \
        w=4e-06 l=1e-06 as=0 ad=1.2e-11 ps=0 pd=1.4e-05 sa=2e-06 sb=2e-06
    MX25_X0_M0_unmatched (Y\#2313 YN\#40 VSS!\#2317 VSS!\#2317) nch \
        w=4e-06 l=1e-06 as=0 ad=1.2e-11 ps=0 pd=1.4e-05 sa=2e-06 sb=2e-06
    MX24_X1_M0_unmatched (Y\#2315 YN\#42 VSS!\#2317 VSS!\#2317) nch \
        w=4e-06 l=1e-06 as=0 ad=1.2e-11 ps=0 pd=1.4e-05 sa=2e-06 sb=2e-06
ends BUFX32_analog_extracted
// End of subcircuit definition.

// Library name: KISTA_SOI_STDLIB2
// Cell name: DFFRX1
// View name: analog_extracted
subckt DFFRX1_analog_extracted D Q QN CK RN
    C40 (Y4\#5 VSS!) capacitor c=13.2934a
    C374 (Y4\#5 10) capacitor c=1.25758e-15
    C62 (Y2\#2313 VSS!) capacitor c=8.96221e-18
    C360 (Y1\#4 Y4\#4) capacitor c=270.273a
    C132 (VDD!\#2311 Q\#5) capacitor c=52.1384a
    C21 (CK\#2 VSS!) capacitor c=17.849a
    C25 (VDD!\#1 VSS!) capacitor c=39.0946a
    C29 (RN VSS!) capacitor c=40.2212a
    C30 (RN\#2310 VSS!) capacitor c=7.29513e-18
    C36 (RN\#2 VSS!) capacitor c=4.30999e-18
    C37 (RN\#6 VSS!) capacitor c=2.26438e-19
    C39 (Y4 VSS!) capacitor c=2.62159e-18
    C42 (Y4\#9 VSS!) capacitor c=1.03413e-18
    C48 (Y4\#2311 VSS!) capacitor c=59.7365a
    C56 (Y2\#2314 VSS!) capacitor c=32.5584a
    C85 (VSS!\#3 10) capacitor c=82.5356f
    C159 (QN\#2 CK) capacitor c=1.07621e-15
    C168 (QN\#2 RN) capacitor c=1.01608e-15
    C170 (RN\#2 QN\#2) capacitor c=14.1018a
    C172 (RN\#6 QN\#2) capacitor c=14.2668a
    C175 (QN\#2 Y4\#7) capacitor c=2.27019e-19
    C179 (Y2\#2314 QN\#2) capacitor c=2.12114e-19
    C186 (QN\#2 10) capacitor c=8.80826e-15
    C201 (RN CK) capacitor c=1.66583e-15
    C204 (CK\#2 RN) capacitor c=7.16119e-18
    C206 (RN\#2 CK) capacitor c=336.543a
    C207 (RN\#2 CK\#2) capacitor c=5.60037e-18
    C208 (RN\#6 CK) capacitor c=328.071a
    C209 (RN\#6 CK\#2) capacitor c=1.0055e-19
    C214 (Y4\#7 CK) capacitor c=30.2186a
    C219 (Y2\#2314 CK) capacitor c=18.6603a
    C221 (CK\#2 Y2\#2314) capacitor c=594.798a
    C226 (10 CK) capacitor c=16.599f
    C231 (CK\#2 10) capacitor c=5.5051e-15
    C254 (VDD!\#1 RN\#2310) capacitor c=236.031a
    C257 (VDD!\#1 Y4\#9) capacitor c=187.863a
    C305 (Y4\#7 RN) capacitor c=424.844a
    C307 (Y4\#9 RN\#2310) capacitor c=337.167a
    C308 (RN\#2 Y4) capacitor c=505.847a
    C309 (RN\#6 Y4\#7) capacitor c=505.852a
    C311 (Y2\#2314 RN) capacitor c=1.4969e-15
    C313 (RN\#2 Y2\#2314) capacitor c=643.68a
    C316 (RN\#6 Y2\#2314) capacitor c=576.995a
    C327 (10 RN) capacitor c=15.0576f
    C328 (RN\#2310 10) capacitor c=1.91813e-15
    C335 (RN\#2 10) capacitor c=5.69841e-15
    C336 (RN\#6 10) capacitor c=5.55804e-15
    C352 (Y2\#2314 Y4) capacitor c=1.11763e-15
    C353 (Y2\#2314 Y4\#7) capacitor c=1.17314e-15
    C378 (Y4\#7 10) capacitor c=32.6009f
    C412 (Y2\#2314 10) capacitor c=24.3509f
    C1 (D\#3 VSS!) capacitor c=15.5462a
    C109 (D\#3 10) capacitor c=1.9308e-15
    C2 (D\#2 VSS!) capacitor c=8.18989e-18
    C104 (D\#2 RN) capacitor c=367.819a
    C107 (Y4\#2311 D\#2) capacitor c=661.777a
    C110 (D\#2 10) capacitor c=2.81139e-15
    C5 (Q\#6 VSS!) capacitor c=13.3087a
    C142 (Y4\#7 Q\#6) capacitor c=586.574a
    C149 (Q\#6 10) capacitor c=6.40896e-15
    C6 (Q\#3 VSS!) capacitor c=10.458a
    C119 (Q\#3 QN\#2) capacitor c=6.83013e-19
    C124 (Q\#3 CK) capacitor c=7.44725e-18
    C126 (CK\#2 Q\#3) capacitor c=1.38509e-19
    C134 (Q\#3 RN) capacitor c=7.05318e-18
    C137 (RN\#2 Q\#3) capacitor c=1.40167e-19
    C143 (Q\#3 Y4\#7) capacitor c=1.12781e-15
    C145 (Y2\#2314 Q\#3) capacitor c=1.0444e-15
    C151 (Q\#3 10) capacitor c=12.5975f
    C7 (Q\#4 VSS!) capacitor c=26.2831a
    C8 (VSS!\#3 Q\#7) capacitor c=59.7099a
    C123 (Q\#7 CK) capacitor c=575.86a
    C133 (Q\#7 RN) capacitor c=570.283a
    C136 (RN\#2 Q\#7) capacitor c=7.91473e-18
    C139 (RN\#6 Q\#7) capacitor c=8.00734e-18
    C144 (Y2\#2314 Q\#7) capacitor c=565.58a
    C150 (Q\#7 10) capacitor c=4.05128e-15
    C10 (QN VSS!) capacitor c=18.3077a
    C116 (Q\#6 QN) capacitor c=831.792a
    C118 (Q\#3 QN) capacitor c=75.859a
    C174 (Y4\#7 QN) capacitor c=1.37896e-15
    C176 (Y2\#2314 QN) capacitor c=1.04424e-15
    C183 (10 QN) capacitor c=9.66853e-15
    C11 (QN\#4 VSS!) capacitor c=12.174a
    C173 (QN\#4 Y4) capacitor c=586.713a
    C177 (Y2\#2314 QN\#4) capacitor c=18.538a
    C184 (QN\#4 10) capacitor c=3.67817e-15
    C12 (QN\#6 VSS!) capacitor c=6.84303e-18
    C187 (QN\#6 10) capacitor c=78.8258a
    C13 (QN\#7 VSS!) capacitor c=15.8182a
    C188 (QN\#7 10) capacitor c=618.171a
    C14 (QN\#2310 VSS!) capacitor c=9.97868e-18
    C189 (QN\#2310 10) capacitor c=315.872a
    C15 (VSS!\#3 QN\#5) capacitor c=73.7603a
    C120 (QN\#5 Q\#7) capacitor c=80.8146a
    C160 (QN\#5 CK) capacitor c=68.4719a
    C190 (QN\#5 10) capacitor c=221.122a
    C17 (VSS!\#5 QN\#2) capacitor c=617.225a
    C9 (VSS!\#5 Q\#2) capacitor c=155.49a
    C122 (Q\#2 QN\#2) capacitor c=97.0997a
    C125 (Q\#2 CK) capacitor c=1.12235e-15
    C127 (CK\#2 Q\#2) capacitor c=19.6909a
    C135 (Q\#2 RN) capacitor c=1.00271e-15
    C138 (RN\#2 Q\#2) capacitor c=19.9267a
    C140 (RN\#6 Q\#2) capacitor c=14.178a
    C152 (Q\#2 10) capacitor c=10.039f
    C16 (VSS!\#5 QN\#3) capacitor c=481.277a
    C121 (Q\#2 QN\#3) capacitor c=138.857a
    C158 (QN\#3 CK) capacitor c=561.315a
    C161 (CK\#2 QN\#3) capacitor c=9.85178e-18
    C167 (QN\#3 RN) capacitor c=564.176a
    C169 (RN\#2 QN\#3) capacitor c=14.6156a
    C171 (RN\#6 QN\#3) capacitor c=7.92159e-18
    C178 (Y2\#2314 QN\#3) capacitor c=497.876a
    C185 (QN\#3 10) capacitor c=5.54369e-15
    C192 (net5\#2 QN\#2) capacitor c=1.83462e-18
    C94 (VSS!\#3 net5\#2) capacitor c=72.6564a
    C154 (net5\#2 Q\#7) capacitor c=83.616a
    C193 (QN\#5 net5\#2) capacitor c=39.8112a
    C148 (Y2\#20 Q\#7) capacitor c=20.2321a
    C67 (Y2\#20 VSS!) capacitor c=5.65137e-19
    C244 (net5\#2 CK) capacitor c=68.4915a
    C318 (Y2\#20 RN) capacitor c=71.7265a
    C319 (Y2\#20 RN\#2) capacitor c=9.95464e-19
    C320 (Y2\#20 RN\#6) capacitor c=43.1559a
    C358 (Y2\#20 Y4\#7) capacitor c=72.9681a
    C417 (Y2\#20 10) capacitor c=683.042a
    C465 (net5\#2 10) capacitor c=221.343a
    C93 (VSS!\#3 net5) capacitor c=73.7603a
    C243 (net5 CK) capacitor c=68.4719a
    C464 (net5 10) capacitor c=221.122a
    C18 (CK\#6 VSS!) capacitor c=23.1835a
    C215 (Y4\#7 CK\#6) capacitor c=499.966a
    C227 (CK\#6 10) capacitor c=3.02001e-15
    C19 (CK\#4 VSS!) capacitor c=23.1294a
    C213 (CK\#4 Y4) capacitor c=586.447a
    C228 (CK\#4 10) capacitor c=3.03501e-15
    C20 (VSS!\#8 CK) capacitor c=331.574a
    C22 (CK\#7 VSS!) capacitor c=9.24328e-19
    C210 (CK\#7 RN) capacitor c=44.0604a
    C211 (CK\#7 RN\#2) capacitor c=6.11498e-19
    C212 (CK\#7 RN\#6) capacitor c=6.18653e-19
    C216 (CK\#7 Y4\#7) capacitor c=1.95288e-18
    C232 (CK\#7 10) capacitor c=397.19a
    C23 (VSS!\#3 CK\#8) capacitor c=66.2249a
    C229 (CK\#8 10) capacitor c=776.482a
    C250 (CK\#7 net11) capacitor c=7.09208e-18
    C97 (VSS!\#3 net11) capacitor c=73.7603a
    C247 (net11 CK) capacitor c=63.8165a
    C248 (CK\#8 net11) capacitor c=83.616a
    C468 (net11 10) capacitor c=221.122a
    C24 (VSS!\#5 CK\#3) capacitor c=67.0147a
    C230 (CK\#3 10) capacitor c=754.181a
    C26 (VDD!\#2316 VSS!) capacitor c=39.3791a
    C103 (VDD!\#2316 D\#3) capacitor c=234.958a
    C27 (VDD!\#21 VSS!) capacitor c=38.3698a
    C162 (QN\#6 VDD!\#21) capacitor c=144.572a
    C28 (VDD!\#9 VSS!) capacitor c=64.0004a
    C130 (VDD!\#9 Q\#6) capacitor c=1.21782e-15
    C31 (RN\#8 VSS!) capacitor c=18.2604a
    C166 (RN\#8 QN) capacitor c=821.924a
    C306 (Y4\#7 RN\#8) capacitor c=26.0672a
    C329 (RN\#8 10) capacitor c=2.47734e-15
    C32 (RN\#4 VSS!) capacitor c=20.0446a
    C303 (RN\#4 Y4) capacitor c=26.0672a
    C330 (RN\#4 10) capacitor c=2.47673e-15
    C38 (VSS!\#3 RN\#7) capacitor c=61.2095a
    C202 (RN\#7 CK) capacitor c=282.784a
    C332 (RN\#7 10) capacitor c=1.36089e-15
    C338 (RN\#7 net5) capacitor c=83.616a
    C41 (Y4\#4 VSS!) capacitor c=2.22023e-18
    C375 (Y4\#4 10) capacitor c=1.21603e-15
    C43 (Y4\#2313 VSS!) capacitor c=3.55018e-18
    C106 (Y4\#2313 D\#3) capacitor c=340.298a
    C258 (VDD!\#2316 Y4\#2313) capacitor c=125.923a
    C386 (Y4\#9 X36_5) capacitor c=406.72a
    C287 (VDD!\#1 X36_5) capacitor c=181.705a
    C348 (RN\#2310 X36_5) capacitor c=508.173a
    C262 (VDD!\#2 Y4\#2313) capacitor c=50.1421a
    C310 (Y4\#2311 RN\#2311) capacitor c=647.161a
    C331 (RN\#2311 10) capacitor c=2.24664e-15
    C115 (D\#3 X35_5) capacitor c=531.824a
    C288 (VDD!\#2316 X35_5) capacitor c=148.996a
    C387 (Y4\#2313 X35_5) capacitor c=148.996a
    C33 (VSS!\#1 RN\#2311) capacitor c=111.117a
    C49 (Y4\#2311 VSS!\#1) capacitor c=50.5731a
    C3 (VSS!\#1 D) capacitor c=70.1673a
    C108 (10 D) capacitor c=746.272a
    C4 (VSS!\#1 D\#1) capacitor c=30.8197a
    C105 (D\#1 RN) capacitor c=295.851a
    C111 (D\#1 10) capacitor c=3.63686e-15
    C114 (net2\#2 D\#1) capacitor c=1.83588e-18
    C102 (net2\#2 VSS!) capacitor c=1.12473e-18
    C113 (net2\#2 D\#2) capacitor c=83.616a
    C347 (net2\#2 RN) capacitor c=51.0237a
    C385 (Y4\#2311 net2\#2) capacitor c=64.1885a
    C475 (net2\#2 10) capacitor c=233.242a
    C34 (VSS!\#1 RN\#9) capacitor c=185.942a
    C334 (RN\#9 10) capacitor c=2.63393e-15
    C346 (RN\#9 net2) capacitor c=77.6958a
    C101 (VSS!\#1 net2) capacitor c=46.0379a
    C345 (RN\#2311 net2) capacitor c=83.616a
    C384 (Y4\#2311 net2) capacitor c=68.4719a
    C474 (net2 10) capacitor c=233.966a
    C343 (RN\#2311 net1) capacitor c=1.12473e-18
    C112 (D\#2 net1) capacitor c=83.616a
    C479 (net2\#2 net1) capacitor c=39.8112a
    C342 (net1 RN) capacitor c=68.4719a
    C382 (Y4\#2311 net1) capacitor c=68.4524a
    C472 (net1 10) capacitor c=233.966a
    C344 (net1\#2 RN) capacitor c=68.4915a
    C383 (Y4\#2311 net1\#2) capacitor c=104.445a
    C473 (net1\#2 10) capacitor c=234.2a
    C44 (Y4\#2314 VSS!) capacitor c=3.19102e-18
    C45 (Y4\#2315 VSS!) capacitor c=2.49485e-18
    C450 (net1\#2 Y3\#2316) capacitor c=83.616a
    C75 (Y3\#2316 VSS!) capacitor c=2.2407e-18
    C321 (Y3\#2316 RN) capacitor c=603.504a
    C371 (Y4\#2311 Y3\#2316) capacitor c=422.842a
    C441 (Y3\#2316 10) capacitor c=2.48754e-15
    C47 (Y4\#2 VSS!) capacitor c=7.6669e-18
    C379 (Y4\#2 10) capacitor c=5.46141e-15
    C50 (VSS!\#3 Y4\#8) capacitor c=70.2146a
    C304 (Y4\#8 RN) capacitor c=292.281a
    C376 (Y4\#8 10) capacitor c=2.82691e-15
    C51 (Y2 VSS!) capacitor c=2.7504e-18
    C351 (Y2 Y4) capacitor c=94.3721a
    C52 (Y2\#2319 VSS!) capacitor c=21.9809a
    C406 (Y2\#2319 10) capacitor c=1.81616e-15
    C53 (Y2\#2317 VSS!) capacitor c=11.6026a
    C146 (Q\#4 Y2\#2317) capacitor c=815.244a
    C407 (Y2\#2317 10) capacitor c=1.80605e-15
    C54 (Y2\#5 VSS!) capacitor c=12.2971a
    C408 (Y2\#5 10) capacitor c=603.937a
    C55 (Y2\#4 VSS!) capacitor c=8.15587e-19
    C411 (Y2\#4 10) capacitor c=1.32015e-15
    C57 (Y2\#7 VSS!) capacitor c=212.284a
    C413 (Y2\#7 10) capacitor c=3.18803e-15
    C58 (VSS!\#7 Y2\#21) capacitor c=181.775a
    C98 (VSS!\#3 net11\#2) capacitor c=105.129a
    C217 (Y2\#21 CK) capacitor c=578.285a
    C249 (net11\#2 CK) capacitor c=65.504a
    C409 (Y2\#21 10) capacitor c=1.9461e-15
    C424 (net11\#2 Y2\#21) capacitor c=83.616a
    C469 (net11\#2 10) capacitor c=221.343a
    C60 (Y2\#9 VSS!) capacitor c=3.25958e-18
    C147 (Y2\#9 Q\#4) capacitor c=99.1849a
    C312 (Y2\#9 RN\#4) capacitor c=814.91a
    C354 (Y2\#9 Y4) capacitor c=67.1879a
    C61 (Y2\#2312 VSS!) capacitor c=9.6027e-18
    C63 (Y2\#8 VSS!) capacitor c=1.39853e-18
    C64 (Y2\#2 VSS!) capacitor c=7.5202e-18
    C355 (Y2\#2 Y4) capacitor c=317.784a
    C414 (Y2\#2 10) capacitor c=3.54381e-15
    C65 (Y2\#3 VSS!) capacitor c=4.96615e-18
    C222 (CK\#2 Y2\#3) capacitor c=5.56464e-18
    C356 (Y2\#3 Y4) capacitor c=317.516a
    C415 (Y2\#3 10) capacitor c=3.99931e-15
    C397 (Y2\#2 Y1\#6) capacitor c=151.857a
    C394 (Y1\#6 Y2) capacitor c=51.6335a
    C395 (Y1\#6 Y2\#5) capacitor c=189.694a
    C399 (Y1\#3 Y2\#3) capacitor c=333.626a
    C362 (Y1\#3 Y4\#2) capacitor c=1.14189e-15
    C361 (Y1\#3 Y4\#3) capacitor c=301.765a
    C377 (Y4\#3 10) capacitor c=2.60616e-15
    C398 (Y1\#3 Y2\#4) capacitor c=422.744a
    C433 (Y1\#3 10) capacitor c=14.1233f
    C46 (VSS!\#6 Y4\#3) capacitor c=185.683a
    C71 (Y1\#3 VSS!\#6) capacitor c=12.5365a
    C380 (net7\#2 Y4\#3) capacitor c=96.4172a
    C86 (net7\#2 VSS!) capacitor c=188.88a
    C420 (net7\#2 Y2\#7) capacitor c=140.014a
    C457 (net7\#2 10) capacitor c=919.612a
    C418 (Y2\#4 net7) capacitor c=109.895a
    C396 (Y1\#5 Y2\#7) capacitor c=54.7346a
    C421 (net9\#2 Y2\#7) capacitor c=34.8346a
    C87 (net9\#2 VSS!) capacitor c=2.80012e-18
    C234 (net9\#2 CK) capacitor c=11.4835a
    C235 (CK\#2 net9\#2) capacitor c=10.5485a
    C419 (Y2\#8 net7) capacitor c=6.07959e-18
    C422 (Y2\#8 net9\#2) capacitor c=83.4762a
    C434 (Y1\#3 net7) capacitor c=113.087a
    C456 (net7 10) capacitor c=460.267a
    C459 (net9\#2 10) capacitor c=915.566a
    C68 (Y1 VSS!) capacitor c=32.8928a
    C359 (Y1 Y4) capacitor c=791.232a
    C391 (Y2\#2314 Y1) capacitor c=717.606a
    C392 (Y2\#8 Y1) capacitor c=76.8586a
    C66 (Y2\#2315 VSS!) capacitor c=3.22647e-18
    C314 (Y2\#2315 RN) capacitor c=561.941a
    C315 (Y2\#2315 RN\#2) capacitor c=14.5577a
    C317 (RN\#6 Y2\#2315) capacitor c=7.89022e-18
    C357 (Y2\#2315 Y4) capacitor c=598.049a
    C141 (Y4 Q) capacitor c=247.626a
    C117 (QN\#4 Q) capacitor c=821.858a
    C416 (Y2\#2315 10) capacitor c=5.46766e-15
    C218 (Y2\#2316 CK) capacitor c=566.061a
    C220 (CK\#2 Y2\#2316) capacitor c=9.93509e-18
    C410 (Y2\#2316 10) capacitor c=1.94715e-15
    C131 (VDD!\#2311 Q\#3) capacitor c=333.906a
    C286 (VDD!\#2311 10) capacitor c=78.4996f
    C59 (VSS!\#9 Y2\#2316) capacitor c=181.872a
    C423 (net4\#2 Y2\#2316) capacitor c=83.616a
    C92 (VSS!\#5 net4\#2) capacitor c=105.129a
    C241 (net4\#2 CK) capacitor c=67.3101a
    C242 (CK\#2 net4\#2) capacitor c=2.36242e-18
    C463 (net4\#2 10) capacitor c=221.343a
    C91 (VSS!\#5 net4) capacitor c=72.6356a
    C153 (Q\#2 net4) capacitor c=41.34a
    C191 (QN\#3 net4) capacitor c=83.616a
    C240 (net4 CK) capacitor c=67.2909a
    C462 (net4 10) capacitor c=221.122a
    C69 (Y1\#7 VSS!) capacitor c=13.3102a
    C431 (Y1\#7 10) capacitor c=2.47005e-15
    C70 (Y1\#9 VSS!) capacitor c=16.1555a
    C393 (Y2\#8 Y1\#9) capacitor c=114.863a
    C432 (Y1\#9 10) capacitor c=831.738a
    C435 (net9\#2 Y1\#9) capacitor c=115.324a
    C88 (VSS!\#5 net9) capacitor c=150.186a
    C233 (CK\#3 net9) capacitor c=84.7217a
    C458 (net9 10) capacitor c=451.872a
    C72 (Y3 VSS!) capacitor c=3.10197e-18
    C180 (Y3 QN) capacitor c=11.4079a
    C363 (Y4\#7 Y3) capacitor c=172.952a
    C401 (Y2\#2319 Y3) capacitor c=738.122a
    C402 (Y2\#2314 Y3) capacitor c=19.8045a
    C403 (Y3\#2 Y2\#2314) capacitor c=538.685a
    C80 (Y3\#2 VSS!) capacitor c=9.87803e-18
    C182 (Y3\#2 QN) capacitor c=11.9237a
    C196 (X28_5 QN) capacitor c=9.91316e-18
    C155 (Q\#6 X28_5) capacitor c=528.86a
    C164 (VDD!\#23 QN\#2310) capacitor c=156.453a
    C197 (QN\#2310 X28_5) capacitor c=210.804a
    C295 (VDD!\#23 X28_5) capacitor c=151.147a
    C367 (Y3\#2 Y4\#7) capacitor c=600.65a
    C404 (Y2\#20 Y3) capacitor c=1.50138e-18
    C405 (Y2\#20 Y3\#2) capacitor c=40.8379a
    C444 (Y3\#2 10) capacitor c=5.41661e-15
    C73 (Y3\#2314 VSS!) capacitor c=12.26a
    C364 (Y4\#2314 Y3\#2314) capacitor c=189.659a
    C439 (Y3\#2314 10) capacitor c=603.558a
    C74 (Y3\#4 VSS!) capacitor c=8.64028e-18
    C181 (QN\#6 Y3\#4) capacitor c=139.36a
    C281 (VDD!\#21 Y3\#4) capacitor c=236.009a
    C440 (Y3\#4 10) capacitor c=615.039a
    C79 (VSS!\#8 Y3\#3) capacitor c=181.775a
    C455 (Y3\#4 X30_5) capacitor c=503.965a
    C194 (QN\#6 X30_5) capacitor c=318.488a
    C238 (net10\#2 CK\#3) capacitor c=83.616a
    C476 (net10\#2 net9) capacitor c=39.0399a
    C251 (net12\#2 CK\#8) capacitor c=83.616a
    C478 (net12\#2 net11) capacitor c=39.8112a
    C339 (net6\#2 RN\#7) capacitor c=83.616a
    C477 (net6\#2 net5) capacitor c=39.8112a
    C368 (Y3\#9 Y4\#7) capacitor c=893.519a
    C372 (Y4\#2311 Y3\#9) capacitor c=530.394a
    C373 (Y4\#2311 Y3\#2315) capacitor c=40.4975a
    C205 (CK\#2 RN\#3) capacitor c=5.04682e-18
    C239 (CK\#2 net10\#2) capacitor c=15.2733a
    C325 (RN\#2 Y3\#3) capacitor c=7.73281e-18
    C326 (RN\#6 Y3\#3) capacitor c=7.82329e-18
    C340 (RN\#6 net6\#2) capacitor c=1.83588e-18
    C270 (VDD!\#29 Y2) capacitor c=19.7488a
    C259 (VDD!\#2317 Y4\#2314) capacitor c=78.277a
    C277 (VDD!\#2317 Y3\#2314) capacitor c=234.766a
    C263 (VDD!\#4 Y4\#2314) capacitor c=53.0681a
    C283 (Y3\#9 VDD!\#2317) capacitor c=23.657a
    C369 (Y3\#9 Y4\#2314) capacitor c=51.5896a
    C388 (Y4\#2314 X34_5) capacitor c=188.398a
    C289 (VDD!\#2317 X34_5) capacitor c=162.469a
    C451 (Y3\#2314 X34_5) capacitor c=533.577a
    C284 (Y3\#2315 VDD!\#2317) capacitor c=2.31801e-18
    C81 (Y3\#9 VSS!) capacitor c=27.1314a
    C82 (Y3\#2315 VSS!) capacitor c=5.33948e-19
    C76 (Y3\#2311 VSS!) capacitor c=9.30753e-18
    C285 (VDD!\#4 Y3\#2311) capacitor c=52.1384a
    C77 (Y3\#2312 VSS!) capacitor c=9.6027e-18
    C78 (Y3\#2313 VSS!) capacitor c=3.39673e-18
    C225 (Y3\#9 CK\#6) capacitor c=819.561a
    C199 (VDD!\#2319 CK\#6) capacitor c=234.793a
    C279 (Y3\#2312 VDD!\#2319) capacitor c=204.098a
    C252 (CK\#6 X32_5) capacitor c=531.824a
    C453 (Y3\#2312 X32_5) capacitor c=148.996a
    C291 (VDD!\#2319 X32_5) capacitor c=148.996a
    C278 (VDD!\#2318 Y3\#2311) capacitor c=103.525a
    C260 (VDD!\#2318 Y4\#5) capacitor c=234.633a
    C365 (Y3\#2311 Y4\#5) capacitor c=244.616a
    C370 (Y3\#2315 Y4\#5) capacitor c=1.17121e-19
    C290 (VDD!\#2318 X33_5) capacitor c=162.469a
    C452 (Y3\#2311 X33_5) capacitor c=188.398a
    C389 (Y4\#5 X33_5) capacitor c=510.168a
    C280 (Y3\#2313 VDD!\#20) capacitor c=204.098a
    C264 (VDD!\#20 Y2\#2319) capacitor c=234.793a
    C292 (VDD!\#20 X31_5) capacitor c=148.996a
    C425 (Y2\#2319 X31_5) capacitor c=531.824a
    C454 (Y3\#2313 X31_5) capacitor c=149.738a
    C282 (VDD!\#21 Y3\#2313) capacitor c=67.3944a
    C293 (VDD!\#21 X30_5) capacitor c=188.398a
    C366 (Y3\#6 Y4\#8) capacitor c=80.8146a
    C84 (VSS!\#3 Y3\#6) capacitor c=73.7811a
    C83 (VSS!\#3 Y3\#5) capacitor c=141.732a
    C95 (VSS!\#3 net6) capacitor c=105.108a
    C96 (VSS!\#3 net6\#2) capacitor c=73.7811a
    C99 (VSS!\#3 net12) capacitor c=72.6356a
    C100 (VSS!\#3 net12\#2) capacitor c=73.7811a
    C381 (Y4\#8 net12) capacitor c=83.616a
    C448 (Y3\#5 net12) capacitor c=1.50952e-18
    C449 (Y3\#6 net12) capacitor c=39.8112a
    C324 (Y3\#6 RN) capacitor c=10.3204a
    C323 (Y3\#5 RN) capacitor c=12.9436a
    C341 (net12 RN) capacitor c=20.635a
    C322 (Y3\#3 RN) capacitor c=557.175a
    C447 (Y3\#3 net6) capacitor c=83.616a
    C470 (net12 10) capacitor c=234.991a
    C442 (Y3\#3 10) capacitor c=3.17729e-15
    C443 (Y3\#5 10) capacitor c=4.20922e-15
    C445 (Y3\#9 10) capacitor c=10.0237f
    C446 (Y3\#2315 10) capacitor c=270.61a
    C466 (net6 10) capacitor c=221.122a
    C245 (net6 CK) capacitor c=68.4719a
    C224 (Y3\#3 CK) capacitor c=575.996a
    C246 (net6\#2 CK) capacitor c=60.7985a
    C467 (net6\#2 10) capacitor c=220.425a
    C471 (net12\#2 10) capacitor c=235.227a
    C203 (RN\#3 CK) capacitor c=287.548a
    C333 (RN\#3 10) capacitor c=1.38264e-15
    C35 (VSS!\#2310 RN\#3) capacitor c=181.691a
    C237 (net10\#2 CK) capacitor c=53.8679a
    C236 (net10 CK) capacitor c=67.2909a
    C337 (RN\#3 net10) capacitor c=83.616a
    C460 (net10 10) capacitor c=221.122a
    C461 (net10\#2 10) capacitor c=221.343a
    C89 (VSS!\#5 net10) capacitor c=105.108a
    C90 (VSS!\#5 net10\#2) capacitor c=72.6564a
    C128 (VDD!\#24 Q\#5) capacitor c=91.3a
    C156 (Q\#5 X27_5) capacitor c=169.256a
    C165 (VDD!\#24 QN\#4) capacitor c=303.376a
    C198 (QN\#4 X27_5) capacitor c=522.459a
    C296 (VDD!\#24 X27_5) capacitor c=154.377a
    C163 (QN\#7 VDD!\#22) capacitor c=230.088a
    C195 (QN\#7 X29_5) capacitor c=445.838a
    C255 (VDD!\#22 RN\#8) capacitor c=235.844a
    C294 (VDD!\#22 X29_5) capacitor c=188.398a
    C349 (RN\#8 X29_5) capacitor c=510.168a
    C129 (Q\#4 VDD!\#25) capacitor c=213.317a
    C157 (Q\#4 X26_5) capacitor c=162.469a
    C265 (VDD!\#25 Y2\#2317) capacitor c=235.812a
    C297 (VDD!\#25 X26_5) capacitor c=188.398a
    C426 (Y2\#2317 X26_5) capacitor c=533.577a
    C256 (VDD!\#26 RN\#4) capacitor c=235.812a
    C266 (Y2\#9 VDD!\#26) capacitor c=213.316a
    C298 (VDD!\#26 X25_5) capacitor c=188.398a
    C350 (RN\#4 X25_5) capacitor c=510.168a
    C427 (Y2\#9 X25_5) capacitor c=162.469a
    C223 (Y2\#2310 CK\#4) capacitor c=821.827a
    C200 (VDD!\#27 CK\#4) capacitor c=234.793a
    C253 (CK\#4 X24_5) capacitor c=531.824a
    C267 (VDD!\#27 Y2\#2312) capacitor c=151.96a
    C299 (VDD!\#27 X24_5) capacitor c=148.996a
    C428 (Y2\#2312 X24_5) capacitor c=148.996a
    C272 (VDD!\#2313 Y2\#2312) capacitor c=52.1384a
    C400 (Y2\#2310 Y1\#7) capacitor c=828.65a
    C273 (VDD!\#28 Y1\#7) capacitor c=234.633a
    C268 (Y2\#2313 VDD!) capacitor c=52.1384a
    C269 (VDD!\#28 Y2\#2313) capacitor c=104.314a
    C300 (VDD!\#28 X23_5) capacitor c=162.469a
    C429 (Y2\#2313 X23_5) capacitor c=188.398a
    C436 (Y1\#7 X23_5) capacitor c=533.577a
    C271 (VDD!\#29 Y2\#5) capacitor c=234.798a
    C274 (Y1\#6 VDD!) capacitor c=49.2406a
    C275 (VDD!\#29 Y1\#6) capacitor c=78.277a
    C301 (VDD!\#29 X22_5) capacitor c=162.469a
    C430 (Y2\#5 X22_5) capacitor c=510.168a
    C437 (Y1\#6 X22_5) capacitor c=188.398a
    C261 (VDD!\#2315 Y4\#4) capacitor c=235.866a
    C276 (Y1\#4 VDD!\#2315) capacitor c=223.193a
    C302 (VDD!\#2315 X21_5) capacitor c=181.705a
    C390 (Y4\#4 X21_5) capacitor c=531.582a
    C438 (Y1\#4 X21_5) capacitor c=406.72a
    MX36_M0_unmatched (Y4\#9 RN\#2310 VDD!\#1 VDD!\#1) pch w=4e-06 l=1e-06 \
        as=0 ad=1e-11 ps=0 pd=1.3e-05 sa=2e-06 sb=2e-06
    MX35_M0_unmatched (Y4\#2313 D\#3 VDD!\#2316 VDD!\#2316) pch w=4e-06 \
        l=1e-06 as=0 ad=1e-11 ps=0 pd=1.3e-05 sa=2e-06 sb=2e-06
    MX28_M0_unmatched (QN\#2310 Q\#6 VDD!\#23 VDD!\#23) pch w=4e-06 \
        l=1e-06 as=0 ad=1e-11 ps=0 pd=1.3e-05 sa=2e-06 sb=2e-06
    MX30_M0_unmatched (QN\#6 Y3\#4 VDD!\#21 VDD!\#21) pch w=4e-06 l=1e-06 \
        as=0 ad=1e-11 ps=0 pd=1.3e-05 sa=2e-06 sb=2e-06
    MX34_M0_unmatched (Y4\#2314 Y3\#2314 VDD!\#2317 VDD!\#2317) pch \
        w=4e-06 l=1e-06 as=0 ad=1e-11 ps=0 pd=1.3e-05 sa=2e-06 sb=2e-06
    MX32_M0_unmatched (Y3\#2312 CK\#6 VDD!\#2319 VDD!\#2319) pch w=4e-06 \
        l=1e-06 as=0 ad=1e-11 ps=0 pd=1.3e-05 sa=2e-06 sb=2e-06
    MX33_M0_unmatched (Y3\#2311 Y4\#5 VDD!\#2318 VDD!\#2318) pch w=4e-06 \
        l=1e-06 as=0 ad=1e-11 ps=0 pd=1.3e-05 sa=2e-06 sb=2e-06
    MX31_M0_unmatched (Y3\#2313 Y2\#2319 VDD!\#20 VDD!\#20) pch w=4e-06 \
        l=1e-06 as=0 ad=1e-11 ps=0 pd=1.3e-05 sa=2e-06 sb=2e-06
    MX27_M0_unmatched (Q\#5 QN\#4 VDD!\#24 VDD!\#24) pch w=4e-06 l=1e-06 \
        as=0 ad=1e-11 ps=0 pd=1.3e-05 sa=2e-06 sb=2e-06
    MX29_M0_unmatched (QN\#7 RN\#8 VDD!\#22 VDD!\#22) pch w=4e-06 l=1e-06 \
        as=0 ad=1e-11 ps=0 pd=1.3e-05 sa=2e-06 sb=2e-06
    MX26_M0_unmatched (Q\#4 Y2\#2317 VDD!\#25 VDD!\#25) pch w=4e-06 \
        l=1e-06 as=0 ad=1e-11 ps=0 pd=1.3e-05 sa=2e-06 sb=2e-06
    MX25_M0_unmatched (Y2\#9 RN\#4 VDD!\#26 VDD!\#26) pch w=4e-06 l=1e-06 \
        as=0 ad=1e-11 ps=0 pd=1.3e-05 sa=2e-06 sb=2e-06
    MX24_M0_unmatched (Y2\#2312 CK\#4 VDD!\#27 VDD!\#27) pch w=4e-06 \
        l=1e-06 as=0 ad=1e-11 ps=0 pd=1.3e-05 sa=2e-06 sb=2e-06
    MX23_M0_unmatched (Y2\#2313 Y1\#7 VDD!\#28 VDD!\#28) pch w=4e-06 \
        l=1e-06 as=0 ad=1e-11 ps=0 pd=1.3e-05 sa=2e-06 sb=2e-06
    MX22_M0_unmatched (Y1\#6 Y2\#5 VDD!\#29 VDD!\#29) pch w=4e-06 l=1e-06 \
        as=0 ad=1e-11 ps=0 pd=1.3e-05 sa=2e-06 sb=2e-06
    MX21_M0_unmatched (Y1\#4 Y4\#4 VDD!\#2315 VDD!\#2315) pch w=4e-06 \
        l=1e-06 as=0 ad=1e-11 ps=0 pd=1.3e-05 sa=2e-06 sb=2e-06
    Rc14 (Y2 Y2\#2313) resistor r=5.5331
    Rc27 (Y1\#3 Y1\#4) resistor r=2.6731
    Rc32 (Q Q\#5) resistor r=2.675
    Rd4 (RN\#2 RN\#6) resistor r=6329.8921
    Rd8 (RN\#6 RN) resistor r=87.8501
    Rd45 (CK\#2 CK) resistor r=86.964
    Rd25 (Y4 Y4\#7) resistor r=2.5
    Rd26 (Y4\#7 Y4\#2311) resistor r=0.298
    Rc82 (RN\#2 RN) resistor r=88.878
    Rc55 (Y4\#9 Y4\#2311) resistor r=3.3574
    Rs1 (10 VSS!) resistor r=50
    Rd48 (D\#2 D\#3) resistor r=1800
    Rc25 (Q\#6 Q\#3) resistor r=2323.2666
    Rc24 (Q\#6 Q\#7) resistor r=3600
    Rc84 (QN\#2 QN) resistor r=1494.3964
    Rd20 (QN QN\#6) resistor r=3.0609
    Rd19 (QN QN\#7) resistor r=3.0009
    Rc69 (QN\#6 QN\#7) resistor r=30.254
    Rd34 (QN QN\#2310) resistor r=2.7528
    Rc85 (QN\#2 QN\#2310) resistor r=40443.4648
    Rd21 (QN\#2 QN\#5) resistor r=10.1
    Rc63 (VSS! VSS!\#5) resistor r=299.7m
    Rc64 (VSS!\#3 VSS!\#5) resistor r=0.401
    Rc33 (Q\#3 Q\#2) resistor r=1445.953
    Rd5 (QN\#3 QN\#4) resistor r=3600
    Rc68 (QN\#3 QN\#2) resistor r=1723.2665
    Rc21 (net5 net5\#2) resistor r=10.1
    Rc2 (Y2\#2314 Y2\#20) resistor r=86.564
    Rc70 (CK\#2 CK\#4) resistor r=3136.0317
    Rc62 (VSS!\#3 VSS!\#8) resistor r=5.0974
    Rc86 (CK\#6 CK\#7) resistor r=3136.0317
    Rc71 (CK\#7 CK) resistor r=85.664
    Rd35 (CK\#7 CK\#8) resistor r=436.0318
    Rd36 (CK\#2 CK\#3) resistor r=436.0318
    Rc67 (RN\#6 RN\#8) resistor r=2536.0317
    Rd7 (RN\#2 RN\#4) resistor r=2536.0317
    Rd6 (RN\#6 RN\#7) resistor r=1036.0317
    Rc49 (Y4\#9 Y4\#2313) resistor r=47.1422
    Rd9 (RN\#2310 RN\#2311) resistor r=1800
    Rc72 (VDD!\#1 VDD!\#2) resistor r=2.6962
    Rd32 (VDD!\#2 VDD!\#2316) resistor r=2.6224
    Rc54 (Y4\#2313 Y4\#2311) resistor r=3.1338
    Rc48 (VSS!\#1 VSS!\#3) resistor r=5.8408
    Rc44 (D D\#1) resistor r=0.1
    Rd47 (D\#1 D\#2) resistor r=1081.957
    Rc95 (RN\#2311 RN\#9) resistor r=476.9571
    Rc83 (RN\#9 RN) resistor r=5.1
    Rc45 (net2 net2\#2) resistor r=10.1
    Rc46 (VSS!\#1 VSS!\#7) resistor r=911.2365
    Rc43 (net1 net1\#2) resistor r=10.1
    Rc47 (VSS!\#7 VSS!\#3) resistor r=5.1589
    Rc50 (Y4\#2311 Y4\#2314) resistor r=2.7545
    Rc52 (Y4\#2311 Y4\#2315) resistor r=7.6419
    Rc56 (Y4\#7 Y4\#2315) resistor r=15.74
    Rd12 (Y4\#2 Y4\#4) resistor r=1336.0317
    Rd11 (Y4\#2 Y4) resistor r=85.464
    Rd28 (Y2\#20 Y2\#2319) resistor r=1936.0317
    Rd18 (Y2\#4 Y2\#7) resistor r=481.9571
    Rc10 (Y2\#20 Y2\#21) resistor r=1636.0317
    Rc31 (net11 net11\#2) resistor r=10.1
    Rd24 (Y2\#7 Y2\#8) resistor r=5.1779
    Rd17 (Y2\#2 Y2) resistor r=85.464
    Rc94 (Y2\#2 Y2\#5) resistor r=736.0318
    Rd16 (Y2\#2 Y2\#3) resistor r=1172.0636
    Rd29 (Y2\#3 Y2\#2314) resistor r=86.264
    Rc79 (Y2\#4 Y2\#3) resistor r=1036.0317
    Rc42 (Y4\#2 Y4\#3) resistor r=2236.0317
    Rc22 (Y1\#3 Y1\#6) resistor r=2.8325
    Rc51 (VSS! VSS!\#6) resistor r=5.0972
    Rc1 (net7 net7\#2) resistor r=10.1779
    Rc20 (Y1\#5 Y1\#3) resistor r=6.2257
    Rc60 (Y1 Y1\#5) resistor r=55.284
    Rc23 (Y1 Y1\#3) resistor r=6.2484
    Rc66 (Y1\#8 Y1) resistor r=80.464
    Rc29 (Y2\#2315 Y2\#2317) resistor r=1936.0317
    Rc30 (Y2\#2315 Y2\#2314) resistor r=85.464
    Rd30 (Y2\#2315 Y2\#2316) resistor r=1636.0317
    Rc26 (Q\#3 Q) resistor r=5.2
    Rd40 (VDD!\#9 VDD!\#2311) resistor r=167.8m
    Rc3 (Q Q\#4) resistor r=2.8529
    Rc57 (VSS!\#3 VSS!\#9) resistor r=62.5645
    Rc58 (VSS!\#9 VSS!\#5) resistor r=5.5851
    Rc15 (net4 net4\#2) resistor r=10.1
    Rc59 (Y1\#7 Y1\#8) resistor r=2536.0317
    Rc61 (Y1\#8 Y1\#9) resistor r=436.0318
    Rc8 (net9 net9\#2) resistor r=10.1779
    Rd1 (VDD!\#9 VDD!\#23) resistor r=2.6224
    Rc35 (Y3\#2 Y3) resistor r=85.464
    Rc11 (Y3\#2 Y3\#4) resistor r=736.0318
    Rd14 (Y3\#2 Y3\#3) resistor r=2836.0317
    Rc88 (VDD!\#2 VDD!\#2317) resistor r=7.9861
    Rd31 (VDD!\#2 VDD!\#4) resistor r=99.5m
    Rd10 (Y3 Y3\#2313) resistor r=4.0799
    Rd39 (Y3 Y3\#9) resistor r=301.5m
    Rc53 (Y4\#6 Y4\#7) resistor r=85.464
    Rd15 (Y3\#2316 Y3\#5) resistor r=1676.9572
    Rd13 (Y3\#2316 Y3\#2315) resistor r=1036.0317
    Rc81 (RN\#2 RN\#3) resistor r=1036.0317
    Rc13 (Y2 Y2\#2310) resistor r=408.9m
    Rc73 (VDD!\#2317 VDD!\#4) resistor r=3.9531
    Rc36 (Y3\#2315 Y3\#2314) resistor r=736.0318
    Rd38 (Y3\#2315 Y3\#9) resistor r=92.1887
    Rc40 (Y3\#2315 Y3\#2311) resistor r=1247.4707
    Rc41 (Y3\#2311 Y3\#9) resistor r=2.8568
    Rc37 (Y3\#9 Y3\#2312) resistor r=2.6545
    Rc39 (Y3\#9 Y3\#2313) resistor r=8.1598
    Rc89 (VDD!\#4 VDD!\#2319) resistor r=5.3108
    Rc74 (VDD!\#2319 VDD!\#6) resistor r=5.3108
    Rd44 (VDD!\#4 VDD!\#6) resistor r=133.7m
    Rd43 (VDD!\#4 VDD!\#2318) resistor r=2.6224
    Rc38 (Y4\#5 Y4\#6) resistor r=1336.0317
    Rd46 (VDD!\#6 VDD!\#20) resistor r=2.6224
    Rc90 (VDD!\#6 VDD!\#7) resistor r=66.01m
    Rd3 (VDD!\#7 VDD!\#21) resistor r=2.6224
    Rd27 (Y4\#6 Y4\#8) resistor r=2236.0317
    Rd37 (Y3\#5 Y3\#6) resistor r=10.1
    Rc28 (net6 net6\#2) resistor r=10.1
    Rc34 (net12 net12\#2) resistor r=10.1
    Rc9 (net10 net10\#2) resistor r=10.1
    Rc65 (VSS!\#5 VSS!\#2310) resistor r=5.0974
    Rd2 (VDD!\#7 VDD!\#9) resistor r=167.8m
    Rc75 (VDD!\#7 VDD!\#22) resistor r=6.6684
    Rc91 (VDD!\#22 VDD!\#9) resistor r=4.4308
    Rc76 (VDD!\#9 VDD!\#24) resistor r=6.6684
    Rc92 (VDD!\#24 VDD!\#2311) resistor r=4.4308
    Rd42 (VDD!\#2311 VDD!\#25) resistor r=2.6224
    Rc77 (VDD!\#2311 VDD!\#26) resistor r=6.6684
    Rc93 (VDD!\#2311 VDD!\#2313) resistor r=167.8m
    Rd49 (VDD!\#26 VDD!\#2313) resistor r=4.4308
    Rd23 (Y2\#2310 Y2\#9) resistor r=2.851
    Rc78 (VDD!\#2313 VDD!\#27) resistor r=2.6224
    Rc12 (Y2\#2310 Y2\#2312) resistor r=2.6545
    Rc80 (VDD!\#2313 VDD!\#28) resistor r=7.9332
    Rd41 (VDD! VDD!\#2313) resistor r=99.84m
    Rd50 (VDD! VDD!\#28) resistor r=3.9666
    Rd22 (Y2\#2310 Y2\#2313) resistor r=5.4796
    Rc87 (VDD! VDD!\#29) resistor r=2.6083
    Rd33 (VDD! VDD!\#2315) resistor r=2.6865
    MX44_M0_unmatched (QN\#5 Q\#7 net5\#2 net5\#2) nch w=2e-06 l=1e-06 \
        as=0 ad=5e-12 ps=0 pd=9e-06 sa=2e-06 sb=2e-06
    MX52_M0_unmatched (net2 RN\#2311 VSS!\#1 VSS!\#1) nch w=2e-06 l=1e-06 \
        as=0 ad=5e-12 ps=0 pd=9e-06 sa=2e-06 sb=2e-06
    MX51_M0_unmatched (net1 D\#2 net2\#2 net2\#2) nch w=2e-06 l=1e-06 as=0 \
        ad=5e-12 ps=0 pd=9e-06 sa=2e-06 sb=2e-06
    MX50_M0_unmatched (Y4\#2315 Y3\#2316 net1\#2 net1\#2) nch w=2e-06 \
        l=1e-06 as=0 ad=5e-12 ps=0 pd=9e-06 sa=2e-06 sb=2e-06
    MX47_M0_unmatched (net11\#2 Y2\#21 VSS!\#7 VSS!\#7) nch w=2e-06 \
        l=1e-06 as=0 ad=5e-12 ps=0 pd=9e-06 sa=2e-06 sb=2e-06
    MX37_M0_unmatched (net7\#2 Y4\#3 VSS!\#6 VSS!\#6) nch w=2e-06 l=1e-06 \
        as=0 ad=5e-12 ps=0 pd=9e-06 sa=2e-06 sb=2e-06
    MX38_M0_unmatched (Y1\#5 Y2\#4 net7 net7) nch w=2e-06 l=1e-06 as=0 \
        ad=5e-12 ps=0 pd=9e-06 sa=2e-06 sb=2e-06
    MX42_M0_unmatched (net4\#2 Y2\#2316 VSS!\#9 VSS!\#9) nch w=2e-06 \
        l=1e-06 as=0 ad=5e-12 ps=0 pd=9e-06 sa=2e-06 sb=2e-06
    MX43_M0_unmatched (Q\#2 QN\#3 net4 net4) nch w=2e-06 l=1e-06 as=0 \
        ad=5e-12 ps=0 pd=9e-06 sa=2e-06 sb=2e-06
    MX39_M0_unmatched (Y2\#8 Y1\#9 net9\#2 net9\#2) nch w=2e-06 l=1e-06 \
        as=0 ad=5e-12 ps=0 pd=9e-06 sa=2e-06 sb=2e-06
    MX46_M0_unmatched (net6 Y3\#3 VSS!\#8 VSS!\#8) nch w=2e-06 l=1e-06 \
        as=0 ad=5e-12 ps=0 pd=9e-06 sa=2e-06 sb=2e-06
    MX40_M0_unmatched (net9 CK\#3 net10\#2 net10\#2) nch w=2e-06 l=1e-06 \
        as=0 ad=5e-12 ps=0 pd=9e-06 sa=2e-06 sb=2e-06
    MX48_M0_unmatched (net12\#2 CK\#8 net11 net11) nch w=2e-06 l=1e-06 \
        as=0 ad=5e-12 ps=0 pd=9e-06 sa=2e-06 sb=2e-06
    MX45_M0_unmatched (net5 RN\#7 net6\#2 net6\#2) nch w=2e-06 l=1e-06 \
        as=0 ad=5e-12 ps=0 pd=9e-06 sa=2e-06 sb=2e-06
    MX49_M0_unmatched (Y3\#6 Y4\#8 net12 net12) nch w=2e-06 l=1e-06 as=0 \
        ad=5e-12 ps=0 pd=9e-06 sa=2e-06 sb=2e-06
    MX41_M0_unmatched (net10 RN\#3 VSS!\#2310 VSS!\#2310) nch w=2e-06 \
        l=1e-06 as=0 ad=5e-12 ps=0 pd=9e-06 sa=2e-06 sb=2e-06
ends DFFRX1_analog_extracted
// End of subcircuit definition.

// Library name: KISTA_SOI_STDLIB2
// Cell name: DFFSX1
// View name: analog_extracted
subckt DFFSX1_analog_extracted D Q SN QN CK
    C39 (Y4\#2313 VSS!) capacitor c=4.68966e-18
    C116 (VDD!\#8 Q\#4) capacitor c=333.906a
    C1 (D\#4 VSS!) capacitor c=4.19769e-18
    C11 (SN VSS!) capacitor c=32.5913a
    C34 (Y4 VSS!) capacitor c=7.63147e-18
    C41 (Y4\#2312 VSS!) capacitor c=44.4445a
    C48 (Y2\#2317 VSS!) capacitor c=42.6034a
    C78 (VSS!\#3 10) capacitor c=75.9712f
    C94 (VDD!\#1 D\#4) capacitor c=239.793a
    C95 (Y4\#9 D\#4) capacitor c=155.445a
    C99 (D\#4 10) capacitor c=2.02949e-15
    C148 (CK SN) capacitor c=569.111a
    C152 (Y4 SN) capacitor c=1.25037e-15
    C159 (Y2\#2317 SN) capacitor c=562.738a
    C169 (10 SN) capacitor c=11.767f
    C222 (Y4\#9 VDD!\#1) capacitor c=144.55a
    C266 (Y4\#6 CK) capacitor c=1.37566e-18
    C267 (Y4\#6 CK\#7) capacitor c=1.09418e-19
    C268 (Y4\#2312 CK) capacitor c=668.61a
    C269 (Y4\#2312 CK\#7) capacitor c=51.2742a
    C277 (10 CK) capacitor c=15.1443f
    C283 (CK\#7 10) capacitor c=779.032a
    C305 (Y2\#2317 Y4) capacitor c=311.151a
    C308 (Y4\#6 Y2\#2317) capacitor c=2.53748e-18
    C310 (Y4\#2312 Y2\#2317) capacitor c=1.18908e-15
    C335 (Y4\#6 10) capacitor c=28.664a
    C336 (Y4\#2312 10) capacitor c=27.85f
    C369 (Y2\#2317 10) capacitor c=20.5811f
    C4 (D\#2 VSS!) capacitor c=6.71444e-18
    C97 (D\#2 Y4\#2312) capacitor c=28.4543a
    C101 (D\#2 10) capacitor c=5.09414e-15
    C103 (D\#4 X37_5) capacitor c=504.33a
    C250 (VDD!\#1 X37_5) capacitor c=479.383a
    C345 (Y4\#9 X37_5) capacitor c=319.404a
    C38 (Y4\#2310 VSS!) capacitor c=6.15639e-18
    C5 (Q VSS!) capacitor c=26.0763a
    C118 (CK Q) capacitor c=1.25663e-15
    C122 (Y4\#6 Q) capacitor c=2.44604e-18
    C125 (Y4\#2312 Q) capacitor c=1.14623e-15
    C136 (10 Q) capacitor c=13.5536f
    C6 (Q\#2310 VSS!) capacitor c=8.03257e-18
    C128 (Y2\#2317 Q\#2310) capacitor c=586.485a
    C137 (Q\#2310 10) capacitor c=6.45432e-15
    C7 (Q\#4 VSS!) capacitor c=8.5777e-18
    C120 (Q\#4 CK) capacitor c=3.52201e-18
    C124 (Y4\#6 Q\#4) capacitor c=1.40533e-20
    C127 (Y4\#2312 Q\#4) capacitor c=6.58549e-18
    C129 (Q\#4 Y2\#2317) capacitor c=1.05231e-15
    C139 (Q\#4 10) capacitor c=10.3809f
    C8 (Q\#6 VSS!) capacitor c=19.0119a
    C130 (Q\#6 Y2\#2317) capacitor c=88.2223a
    C9 (VSS!\#3 Q\#2311) capacitor c=62.1668a
    C119 (Q\#2311 CK) capacitor c=555.248a
    C121 (CK\#7 Q\#2311) capacitor c=44.1637a
    C123 (Y4\#6 Q\#2311) capacitor c=1.29856e-18
    C126 (Y4\#2312 Q\#2311) capacitor c=608.515a
    C138 (Q\#2311 10) capacitor c=4.10196e-15
    C10 (VSS!\#3 Q\#3) capacitor c=157.255a
    C106 (QN\#2 Q) capacitor c=72.7298a
    C194 (QN\#2 CK) capacitor c=652.668a
    C196 (CK\#7 QN\#2) capacitor c=40.6142a
    C201 (Y4\#6 QN\#2) capacitor c=2.43971e-18
    C203 (Y4\#2312 QN\#2) capacitor c=1.08645e-15
    C212 (QN\#2 10) capacitor c=13.4692f
    C12 (SN\#6 VSS!) capacitor c=15.4147a
    C104 (Q\#6 SN\#6) capacitor c=820.551a
    C170 (SN\#6 10) capacitor c=2.47694e-15
    C13 (SN\#4 VSS!) capacitor c=2.58726e-18
    C171 (SN\#4 10) capacitor c=2.54547e-15
    C15 (SN\#2 VSS!) capacitor c=6.40453e-18
    C153 (SN\#2 Y4) capacitor c=2.14696e-18
    C174 (SN\#2 10) capacitor c=5.63069e-15
    C16 (SN\#7 VSS!) capacitor c=9.80901e-19
    C151 (SN\#7 CK) capacitor c=26.2309a
    C156 (SN\#7 Y4) capacitor c=43.7313a
    C162 (SN\#7 Y2\#2317) capacitor c=32.5369a
    C175 (SN\#7 10) capacitor c=393.975a
    C18 (QN\#5 VSS!) capacitor c=22.8705a
    C198 (QN\#5 Y4) capacitor c=15.871a
    C204 (Y2\#2317 QN\#5) capacitor c=547.574a
    C210 (QN\#5 10) capacitor c=3.70259e-15
    C19 (QN\#8 VSS!) capacitor c=34.4124a
    C107 (QN\#8 Q\#2310) capacitor c=830.154a
    C108 (QN\#8 Q\#4) capacitor c=83.1637a
    C205 (QN\#8 Y2\#2317) capacitor c=1.22178e-15
    C20 (VSS!\#3 QN\#3) capacitor c=609.51a
    C110 (Q\#3 QN\#3) capacitor c=119.102a
    C195 (QN\#3 CK) capacitor c=526.288a
    C197 (CK\#7 QN\#3) capacitor c=30.3123a
    C213 (QN\#3 10) capacitor c=5.5175e-15
    C21 (VSS!\#3 QN\#6) capacitor c=72.6356a
    C23 (VDD!\#2319 VSS!) capacitor c=36.2891a
    C24 (VDD!\#27 VSS!) capacitor c=36.6029a
    C25 (VDD!\#2314 VSS!) capacitor c=38.2754a
    C147 (VDD!\#2314 SN\#4) capacitor c=236.031a
    C26 (VDD!\#7 VSS!) capacitor c=56.8827a
    C115 (VDD!\#7 Q\#2310) capacitor c=1.21451e-15
    C27 (CK\#6 VSS!) capacitor c=27.6286a
    C278 (CK\#6 10) capacitor c=3.20525e-15
    C28 (CK\#4 VSS!) capacitor c=30.8672a
    C279 (CK\#4 10) capacitor c=3.18677e-15
    C29 (VSS!\#9 CK) capacitor c=302.165a
    C32 (CK\#7 VSS!\#7) capacitor c=11.7101a
    C33 (VSS!\#3 CK\#8) capacitor c=67.2465a
    C280 (CK\#8 10) capacitor c=784.744a
    C35 (Y4\#5 VSS!) capacitor c=13.3327a
    C330 (Y4\#5 10) capacitor c=1.82229e-15
    C36 (Y4\#4 VSS!) capacitor c=20.0739a
    C225 (VDD!\#27 Y4\#4) capacitor c=234.958a
    C331 (Y4\#4 10) capacitor c=1.93084e-15
    C37 (Y4\#3 VSS!) capacitor c=71.9342a
    C333 (Y4\#3 10) capacitor c=2.13172e-15
    C40 (Y4\#2 VSS!) capacitor c=8.0678e-18
    C154 (Y4\#2 SN) capacitor c=579.826a
    C155 (Y4\#2 SN\#2) capacitor c=6.106e-18
    C334 (Y4\#2 10) capacitor c=5.49677e-15
    C42 (VSS!\#3 Y4\#8) capacitor c=13.1181a
    C332 (Y4\#8 10) capacitor c=1.53153e-15
    C43 (Y2 VSS!) capacitor c=4.51706e-18
    C44 (Y2\#2318 VSS!) capacitor c=22.0038a
    C363 (Y2\#2318 10) capacitor c=1.2281e-15
    C45 (Y2\#2316 VSS!) capacitor c=8.64028e-18
    C364 (Y2\#2316 10) capacitor c=615.039a
    C46 (Y2\#4 VSS!) capacitor c=12.2606a
    C365 (Y2\#4 10) capacitor c=603.937a
    C47 (Y2\#3 VSS!) capacitor c=64.3543a
    C158 (Y2\#3 SN) capacitor c=1.15868e-15
    C160 (SN\#2 Y2\#3) capacitor c=12.2017a
    C304 (Y2\#3 Y4) capacitor c=1.48862e-15
    C368 (Y2\#3 10) capacitor c=7.48169e-15
    C49 (VSS!\#7 Y2\#20) capacitor c=182.918a
    C270 (Y2\#20 CK) capacitor c=556.078a
    C273 (CK\#7 Y2\#20) capacitor c=44.2297a
    C366 (Y2\#20 10) capacitor c=2.61812e-15
    C50 (VSS!\#9 Y2\#2315) capacitor c=182.446a
    C157 (Y2\#2315 SN) capacitor c=288.962a
    C271 (Y2\#2315 CK) capacitor c=578.939a
    C367 (Y2\#2315 10) capacitor c=2.54359e-15
    C51 (Y2\#2310 VSS!) capacitor c=3.39673e-18
    C52 (Y2\#2311 VSS!) capacitor c=8.82143e-18
    C53 (Y2\#6 VSS!) capacitor c=3.43237e-18
    C54 (Y2\#2 VSS!) capacitor c=19.7143a
    C371 (Y2\#2 10) capacitor c=4.44785e-15
    C356 (Y1\#4 Y2\#2) capacitor c=764.351a
    C61 (Y1\#4 VSS!) capacitor c=51.7048a
    C166 (Y1\#4 SN\#2) capacitor c=543.591a
    C312 (Y1\#4 Y4) capacitor c=589.164a
    C313 (Y1\#4 Y4\#2) capacitor c=670.883a
    C339 (Y4\#2 net7) capacitor c=2.06098e-18
    C180 (net7 SN) capacitor c=50.3561a
    C182 (SN\#2 net7) capacitor c=5.30288e-19
    C355 (Y1\#4 Y2) capacitor c=136.709a
    C374 (Y2\#3 net7) capacitor c=206.908a
    C388 (Y1\#4 10) capacitor c=17.5391f
    C416 (net7 10) capacitor c=367.614a
    C55 (Y2\#2313 VSS!) capacitor c=6.17885e-18
    C132 (Y2\#2313 Q\#4) capacitor c=75.1085a
    C161 (Y2\#2313 SN) capacitor c=325.054a
    C163 (SN\#7 Y2\#2313) capacitor c=2.32232e-18
    C206 (Y2\#2313 QN\#5) capacitor c=39.0831a
    C306 (Y2\#2313 Y4) capacitor c=632.471a
    C309 (Y4\#6 Y2\#2313) capacitor c=2.00297e-20
    C372 (Y2\#2313 10) capacitor c=4.78739e-15
    C56 (Y2\#2314 VSS!) capacitor c=2.59784e-19
    C133 (Y2\#2314 Q\#6) capacitor c=1.61062e-18
    C307 (Y2\#2314 Y4) capacitor c=7.60574e-19
    C373 (Y2\#2314 10) capacitor c=192.326a
    C135 (Q\#5 Y2\#2313) capacitor c=16.9975a
    C111 (Q\#5 QN\#5) capacitor c=821.858a
    C134 (Q\#5 Y2\#2317) capacitor c=175.342a
    C58 (Y1\#9 VSS!) capacitor c=13.3271a
    C350 (Y2\#2311 Y1\#9) capacitor c=244.733a
    C386 (Y1\#9 10) capacitor c=1.25758e-15
    C59 (Y1\#2 VSS!) capacitor c=18.4189a
    C354 (Y1\#2 Y2\#3) capacitor c=182.054a
    C391 (Y1\#2 net7) capacitor c=47.5918a
    C164 (Y1 SN) capacitor c=1.42527e-15
    C349 (Y2\#5 Y1) capacitor c=118.543a
    C351 (Y2\#6 Y1) capacitor c=66.6755a
    C63 (Y1\#2311 VSS!) capacitor c=1.06053e-18
    C167 (Y1\#2311 SN) capacitor c=1.62956e-15
    C168 (Y1\#2311 SN\#2) capacitor c=9.21832e-19
    C315 (Y1\#2311 Y4) capacitor c=303.909a
    C357 (Y1\#2311 Y2\#6) capacitor c=15.3045a
    C370 (Y2\#5 10) capacitor c=4.02162e-15
    C390 (Y1\#2311 10) capacitor c=3.49607e-15
    C57 (VSS!\#5 Y2\#5) capacitor c=231.167a
    C379 (net3\#2 Y2\#2315) capacitor c=83.616a
    C85 (VSS!\#5 net3\#2) capacitor c=104.004a
    C288 (net3\#2 CK) capacitor c=68.4915a
    C421 (net3\#2 10) capacitor c=221.343a
    C17 (VSS!\#5 SN\#8) capacitor c=61.3824a
    C149 (SN\#8 CK) capacitor c=282.784a
    C172 (SN\#8 10) capacitor c=1.36081e-15
    C186 (SN\#7 net3) capacitor c=1.11442e-19
    C84 (VSS!\#5 net3) capacitor c=73.7603a
    C184 (net3 SN) capacitor c=1.72444e-18
    C185 (SN\#8 net3) capacitor c=83.616a
    C287 (net3 CK) capacitor c=60.7789a
    C420 (net3 10) capacitor c=220.204a
    C289 (net3\#2 CK\#3) capacitor c=1.12473e-18
    C281 (CK\#3 10) capacitor c=759.296a
    C22 (VSS!\#5 QN\#4) capacitor c=496.313a
    C109 (Q\#3 QN\#4) capacitor c=242.567a
    C193 (QN\#4 CK) capacitor c=594.891a
    C199 (QN\#4 Y4) capacitor c=527.23a
    C200 (Y4\#6 QN\#4) capacitor c=5.53091e-19
    C211 (QN\#4 10) capacitor c=5.65353e-15
    C215 (net6\#2 QN\#3) capacitor c=1.83462e-18
    C89 (VSS!\#3 net6\#2) capacitor c=72.6564a
    C141 (net6\#2 Q\#2311) capacitor c=83.616a
    C216 (QN\#6 net6\#2) capacitor c=39.8112a
    C105 (Q\#2311 QN) capacitor c=185.07a
    C202 (Y4\#2312 QN) capacitor c=56.8151a
    C190 (QN\#7 VDD!\#2319) capacitor c=144.572a
    C293 (net6\#2 CK) capacitor c=63.4452a
    C294 (CK\#7 net6\#2) capacitor c=10.0912a
    C425 (net6\#2 10) capacitor c=221.343a
    C88 (VSS!\#3 net6) capacitor c=105.108a
    C292 (net6 CK) capacitor c=63.427a
    C424 (net6 10) capacitor c=221.122a
    C30 (VSS!\#2310 CK\#3) capacitor c=187.137a
    C31 (CK\#2 VSS!\#2310) capacitor c=14.5488a
    C83 (VSS!\#5 net9) capacitor c=120.707a
    C150 (CK\#2 SN) capacitor c=609.738a
    C265 (CK\#2 Y4) capacitor c=612.647a
    C314 (Y1\#2310 Y4) capacitor c=24.6063a
    C62 (Y1\#2310 VSS!) capacitor c=1.2982e-18
    C282 (CK\#2 10) capacitor c=5.35847e-15
    C284 (CK\#3 net9) capacitor c=101.713a
    C377 (Y2\#5 net9) capacitor c=9.41027e-18
    C375 (net7\#2 Y2\#5) capacitor c=7.92231e-18
    C81 (net7\#2 VSS!) capacitor c=69.274a
    C338 (net7\#2 Y4\#3) capacitor c=221.572a
    C376 (net7\#2 Y2\#6) capacitor c=1.03341e-18
    C389 (Y1\#2310 10) capacitor c=308.384a
    C417 (net7\#2 10) capacitor c=232.025a
    C418 (net9 10) capacitor c=510.436a
    C82 (net9\#2 VSS!) capacitor c=1.54983e-18
    C183 (net9\#2 SN) capacitor c=136.445a
    C285 (net9\#2 CK) capacitor c=42.4576a
    C286 (CK\#2 net9\#2) capacitor c=128.953a
    C378 (Y2\#6 net9\#2) capacitor c=52.2629a
    C419 (net9\#2 10) capacitor c=901.451a
    C64 (VSS!\#5 Y1\#2312) capacitor c=12.257a
    C352 (Y2\#6 Y1\#2312) capacitor c=115.495a
    C392 (net9\#2 Y1\#2312) capacitor c=87.2498a
    C387 (Y1\#2312 10) capacitor c=840.282a
    C181 (SN\#3 net7) capacitor c=2.90054e-18
    C173 (SN\#3 10) capacitor c=1.40407e-15
    C179 (SN\#2 net8\#2) capacitor c=3.98171e-18
    C80 (net8\#2 VSS!) capacitor c=104.004a
    C177 (net8\#2 SN) capacitor c=8.04463e-18
    C176 (net8 SN) capacitor c=10.21a
    C79 (net8 VSS!) capacitor c=76.0093a
    C178 (net8\#2 SN\#3) capacitor c=83.616a
    C337 (Y4\#3 net8) capacitor c=83.3415a
    C432 (net7\#2 net8) capacitor c=46.0379a
    C414 (net8 10) capacitor c=234.991a
    C415 (net8\#2 10) capacitor c=296.794a
    C14 (VSS!\#6 SN\#3) capacitor c=167.567a
    C359 (Y2\#8 Y1\#2310) capacitor c=43.697a
    C272 (Y2\#8 CK\#4) capacitor c=840.346a
    C358 (Y2\#8 Y1\#4) capacitor c=599.312a
    C234 (Y2\#2314 VDD!\#23) capacitor c=1.50063e-18
    C227 (VDD!\#23 Y2\#2316) capacitor c=236.503a
    C228 (Y2\#2310 VDD!\#23) capacitor c=123.469a
    C232 (VDD!\#26 Y2) capacitor c=19.7488a
    C233 (VDD!\#26 Y2\#4) capacitor c=234.798a
    C60 (Y1\#6 VSS!) capacitor c=10.0074a
    C165 (Y1\#6 SN\#4) capacitor c=415.439a
    C239 (Y1\#6 VDD!\#2314) capacitor c=194.385a
    C189 (SN\#4 X23_5) capacitor c=531.582a
    C264 (VDD!\#2314 X23_5) capacitor c=181.705a
    C396 (Y1\#6 X23_5) capacitor c=406.72a
    C230 (Y2\#2311 VDD!) capacitor c=52.1384a
    C238 (Y1\#8 VDD!\#27) capacitor c=176.041a
    C311 (Y1\#8 Y4\#4) capacitor c=335.337a
    C236 (Y1\#7 VDD!) capacitor c=53.0681a
    C237 (VDD!\#26 Y1\#7) capacitor c=78.277a
    C353 (Y1\#7 Y2\#4) capacitor c=189.694a
    C262 (VDD!\#26 X25_5) capacitor c=162.469a
    C385 (Y2\#4 X25_5) capacitor c=510.168a
    C394 (Y1\#7 X25_5) capacitor c=188.398a
    C263 (VDD!\#27 X24_5) capacitor c=148.996a
    C348 (Y4\#4 X24_5) capacitor c=531.824a
    C395 (Y1\#8 X24_5) capacitor c=148.996a
    C65 (Y3 VSS!) capacitor c=3.10197e-18
    C208 (QN\#8 Y3) capacitor c=10.8556a
    C360 (Y2\#2317 Y3) capacitor c=731.745a
    C66 (Y3\#2314 VSS!) capacitor c=5.83465e-18
    C316 (Y4\#2310 Y3\#2314) capacitor c=194.696a
    C397 (Y3\#2314 10) capacitor c=593.04a
    C67 (Y3\#4 VSS!) capacitor c=8.71067e-18
    C207 (QN\#7 Y3\#4) capacitor c=139.36a
    C244 (VDD!\#2319 Y3\#4) capacitor c=236.009a
    C398 (Y3\#4 10) capacitor c=615.039a
    C217 (QN\#7 X32_5) capacitor c=318.488a
    C255 (VDD!\#2319 X32_5) capacitor c=188.398a
    C413 (Y3\#4 X32_5) capacitor c=503.965a
    C74 (Y3\#2 VSS!) capacitor c=5.50989e-18
    C209 (Y3\#2 QN\#8) capacitor c=15.8507a
    C320 (Y4\#6 Y3\#2) capacitor c=1.30464e-18
    C327 (Y4\#2312 Y3\#2) capacitor c=611.364a
    C362 (Y3\#2 Y2\#2317) capacitor c=596.52a
    C402 (Y3\#2 10) capacitor c=5.39839e-15
    C274 (Y3\#3 CK) capacitor c=556.35a
    C275 (CK\#7 Y3\#3) capacitor c=44.2514a
    C400 (Y3\#3 10) capacitor c=3.2859e-15
    C405 (Y3\#3 net6) capacitor c=83.616a
    C73 (VSS!\#8 Y3\#3) capacitor c=185.47a
    C68 (Y3\#2316 VSS!) capacitor c=6.0987e-18
    C326 (Y4\#2312 Y3\#2316) capacitor c=564.044a
    C399 (Y3\#2316 10) capacitor c=2.6075e-15
    C70 (Y3\#2311 VSS!) capacitor c=9.3157e-18
    C71 (Y3\#2312 VSS!) capacitor c=9.6027e-18
    C72 (Y3\#2313 VSS!) capacitor c=3.44212e-18
    C245 (VDD!\#2319 Y3\#2313) capacitor c=67.3944a
    C361 (Y3\#2313 Y2\#2318) capacitor c=242.596a
    C380 (net11\#2 Y2\#20) capacitor c=83.616a
    C140 (Q\#3 net4) capacitor c=41.34a
    C214 (QN\#4 net4) capacitor c=83.616a
    C187 (net4\#2 SN\#8) capacitor c=83.616a
    C433 (net4\#2 net3) capacitor c=39.8112a
    C75 (Y3\#9 VSS!) capacitor c=32.3431a
    C76 (Y3\#2315 VSS!) capacitor c=3.29276e-19
    C323 (Y3\#9 Y4\#6) capacitor c=1.66894e-19
    C325 (Y3\#2315 Y4\#6) capacitor c=2.39915e-22
    C298 (CK\#7 net11\#2) capacitor c=10.0521a
    C301 (CK\#7 net12\#2) capacitor c=12.7571a
    C86 (VSS!\#5 net4) capacitor c=72.6356a
    C87 (VSS!\#5 net4\#2) capacitor c=73.7811a
    C142 (Q\#2310 X31_5) capacitor c=507.204a
    C223 (Y4\#2310 VDD!\#2315) capacitor c=157.494a
    C240 (VDD!\#2315 Y3\#2314) capacitor c=236.315a
    C246 (Y3\#9 VDD!\#2315) capacitor c=23.657a
    C322 (Y3\#9 Y4\#2310) capacitor c=205.299a
    C346 (Y4\#2310 X36_5) capacitor c=501.364a
    C251 (VDD!\#2315 X36_5) capacitor c=182.829a
    C409 (Y3\#2314 X36_5) capacitor c=511.921a
    C247 (Y3\#2315 VDD!\#2315) capacitor c=2.31801e-18
    C276 (Y3\#9 CK\#6) capacitor c=844.145a
    C220 (VDD!\#2317 CK\#6) capacitor c=234.793a
    C242 (Y3\#2312 VDD!\#2317) capacitor c=204.098a
    C302 (CK\#6 X34_5) capacitor c=531.824a
    C411 (Y3\#2312 X34_5) capacitor c=148.996a
    C253 (VDD!\#2317 X34_5) capacitor c=148.996a
    C321 (Y3\#9 Y4\#5) capacitor c=745.409a
    C324 (Y3\#2315 Y4\#5) capacitor c=1.18505e-18
    C224 (VDD!\#2316 Y4\#5) capacitor c=234.633a
    C241 (VDD!\#2316 Y3\#2311) capacitor c=103.525a
    C347 (Y4\#5 X35_5) capacitor c=510.168a
    C252 (VDD!\#2316 X35_5) capacitor c=162.469a
    C410 (Y3\#2311 X35_5) capacitor c=188.398a
    C248 (VDD!\#3 Y3\#2311) capacitor c=52.1384a
    C249 (VDD!\#3 10) capacitor c=73.9846f
    C403 (Y3\#9 10) capacitor c=12.0272f
    C404 (Y3\#2315 10) capacitor c=351.461a
    C98 (10 D) capacitor c=1.35022e-15
    C2 (VSS!\#1 D) capacitor c=49.2015a
    C3 (VSS!\#1 D\#3) capacitor c=135.282a
    C100 (D\#3 10) capacitor c=1.48451e-15
    C69 (VSS!\#1 Y3\#5) capacitor c=154.182a
    C401 (Y3\#5 10) capacitor c=2.7738e-15
    C93 (VSS!\#1 net1) capacitor c=73.0223a
    C102 (D\#3 net1) capacitor c=83.616a
    C430 (net1 10) capacitor c=251.403a
    C96 (Y4\#2312 D) capacitor c=14.8452a
    C328 (Y4\#2312 Y3\#9) capacitor c=522.335a
    C329 (Y4\#2312 Y3\#2315) capacitor c=43.5407a
    C431 (net1\#2 10) capacitor c=229.802a
    C226 (VDD!\#2318 Y2\#2318) capacitor c=234.793a
    C243 (Y3\#2313 VDD!\#2318) capacitor c=204.098a
    C254 (VDD!\#2318 X33_5) capacitor c=148.996a
    C381 (Y2\#2318 X33_5) capacitor c=531.824a
    C412 (Y3\#2313 X33_5) capacitor c=149.738a
    C408 (net1\#2 Y3\#2316) capacitor c=83.616a
    C317 (Y4\#2313 Y3\#5) capacitor c=56.3609a
    C344 (Y4\#2313 net1\#2) capacitor c=59.8477a
    C319 (Y3\#6 Y4\#2313) capacitor c=28.8482a
    C343 (net1\#2 Y4\#8) capacitor c=1.12473e-18
    C318 (Y3\#6 Y4\#8) capacitor c=104.251a
    C407 (net12\#2 Y3\#5) capacitor c=1.372e-18
    C342 (Y4\#2312 net12\#2) capacitor c=8.83213e-18
    C341 (Y4\#2312 net12) capacitor c=17.4297a
    C340 (Y4\#8 net12) capacitor c=87.3632a
    C406 (Y3\#6 net12) capacitor c=55.7448a
    C77 (VSS!\#3 Y3\#6) capacitor c=71.0785a
    C92 (VSS!\#3 net12\#2) capacitor c=85.7666a
    C428 (net12 10) capacitor c=546.443a
    C429 (net12\#2 10) capacitor c=949.665a
    C91 (VSS!\#3 net11\#2) capacitor c=105.129a
    C90 (VSS!\#3 net11) capacitor c=72.6356a
    C426 (net11 10) capacitor c=221.122a
    C427 (net11\#2 10) capacitor c=221.343a
    C434 (net12\#2 net11) capacitor c=46.0379a
    C295 (net11 CK) capacitor c=62.9349a
    C297 (net11\#2 CK) capacitor c=63.4452a
    C299 (net12\#2 CK) capacitor c=160.388a
    C290 (net4 CK) capacitor c=68.4719a
    C291 (net4\#2 CK) capacitor c=68.4915a
    C422 (net4 10) capacitor c=221.122a
    C423 (net4\#2 10) capacitor c=221.343a
    C296 (CK\#8 net11) capacitor c=83.616a
    C300 (net12\#2 CK\#8) capacitor c=101.713a
    C112 (VDD!\#21 Q\#9) capacitor c=91.3a
    C117 (VDD!\#8 Q\#9) capacitor c=52.1384a
    C143 (Q\#9 X30_5) capacitor c=169.256a
    C257 (VDD!\#21 X30_5) capacitor c=154.377a
    C219 (QN\#5 X30_5) capacitor c=522.458a
    C192 (VDD!\#21 QN\#5) capacitor c=303.376a
    C114 (Q\#8 VDD!\#23) capacitor c=143.006a
    C131 (Q\#8 Y2\#2316) capacitor c=141.206a
    C382 (Y2\#2316 X28_5) capacitor c=480.556a
    C145 (Q\#8 X28_5) capacitor c=318.488a
    C259 (VDD!\#23 X28_5) capacitor c=188.398a
    C113 (Q\#6 VDD!\#22) capacitor c=230.559a
    C144 (Q\#6 X29_5) capacitor c=445.838a
    C146 (VDD!\#22 SN\#6) capacitor c=235.812a
    C188 (SN\#6 X29_5) capacitor c=533.577a
    C258 (VDD!\#22 X29_5) capacitor c=188.398a
    C221 (VDD!\#24 CK\#4) capacitor c=234.793a
    C229 (VDD!\#24 Y2\#2310) capacitor c=151.96a
    C260 (VDD!\#24 X27_5) capacitor c=148.996a
    C303 (CK\#4 X27_5) capacitor c=531.824a
    C383 (Y2\#2310 X27_5) capacitor c=149.738a
    C231 (VDD!\#25 Y2\#2311) capacitor c=104.314a
    C235 (VDD!\#25 Y1\#9) capacitor c=234.633a
    C261 (VDD!\#25 X26_5) capacitor c=162.469a
    C384 (Y2\#2311 X26_5) capacitor c=188.398a
    C393 (Y1\#9 X26_5) capacitor c=533.577a
    C191 (QN\#8 VDD!\#20) capacitor c=182.858a
    C218 (QN\#8 X31_5) capacitor c=509.303a
    C256 (VDD!\#20 X31_5) capacitor c=192.097a
    MX37_M0_unmatched (Y4\#9 D\#4 VDD!\#1 VDD!\#1) pch w=4e-06 l=1e-06 \
        as=0 ad=1e-11 ps=0 pd=1.3e-05 sa=2e-06 sb=2e-06
    MX23_M0_unmatched (Y1\#6 SN\#4 VDD!\#2314 VDD!\#2314) pch w=4e-06 \
        l=1e-06 as=0 ad=1e-11 ps=0 pd=1.3e-05 sa=2e-06 sb=2e-06
    MX25_M0_unmatched (Y1\#7 Y2\#4 VDD!\#26 VDD!\#26) pch w=4e-06 l=1e-06 \
        as=0 ad=1e-11 ps=0 pd=1.3e-05 sa=2e-06 sb=2e-06
    MX24_M0_unmatched (Y1\#8 Y4\#4 VDD!\#27 VDD!\#27) pch w=4e-06 l=1e-06 \
        as=0 ad=1e-11 ps=0 pd=1.3e-05 sa=2e-06 sb=2e-06
    MX32_M0_unmatched (QN\#7 Y3\#4 VDD!\#2319 VDD!\#2319) pch w=4e-06 \
        l=1e-06 as=0 ad=1e-11 ps=0 pd=1.3e-05 sa=2e-06 sb=2e-06
    MX31_M0_unmatched (QN\#8 Q\#2310 VDD!\#20 VDD!\#20) pch w=4e-06 \
        l=1e-06 as=0 ad=1e-11 ps=0 pd=1.3e-05 sa=2e-06 sb=2e-06
    MX36_M0_unmatched (Y4\#2310 Y3\#2314 VDD!\#2315 VDD!\#2315) pch \
        w=4e-06 l=1e-06 as=0 ad=1e-11 ps=0 pd=1.3e-05 sa=2e-06 sb=2e-06
    MX34_M0_unmatched (Y3\#2312 CK\#6 VDD!\#2317 VDD!\#2317) pch w=4e-06 \
        l=1e-06 as=0 ad=1e-11 ps=0 pd=1.3e-05 sa=2e-06 sb=2e-06
    MX35_M0_unmatched (Y3\#2311 Y4\#5 VDD!\#2316 VDD!\#2316) pch w=4e-06 \
        l=1e-06 as=0 ad=1e-11 ps=0 pd=1.3e-05 sa=2e-06 sb=2e-06
    MX33_M0_unmatched (Y3\#2313 Y2\#2318 VDD!\#2318 VDD!\#2318) pch \
        w=4e-06 l=1e-06 as=0 ad=1e-11 ps=0 pd=1.3e-05 sa=2e-06 sb=2e-06
    MX30_M0_unmatched (Q\#9 QN\#5 VDD!\#21 VDD!\#21) pch w=4e-06 l=1e-06 \
        as=0 ad=1e-11 ps=0 pd=1.3e-05 sa=2e-06 sb=2e-06
    MX28_M0_unmatched (Q\#8 Y2\#2316 VDD!\#23 VDD!\#23) pch w=4e-06 \
        l=1e-06 as=0 ad=1e-11 ps=0 pd=1.3e-05 sa=2e-06 sb=2e-06
    MX29_M0_unmatched (Q\#6 SN\#6 VDD!\#22 VDD!\#22) pch w=4e-06 l=1e-06 \
        as=0 ad=1e-11 ps=0 pd=1.3e-05 sa=2e-06 sb=2e-06
    MX27_M0_unmatched (Y2\#2310 CK\#4 VDD!\#24 VDD!\#24) pch w=4e-06 \
        l=1e-06 as=0 ad=1e-11 ps=0 pd=1.3e-05 sa=2e-06 sb=2e-06
    MX26_M0_unmatched (Y2\#2311 Y1\#9 VDD!\#25 VDD!\#25) pch w=4e-06 \
        l=1e-06 as=0 ad=1e-11 ps=0 pd=1.3e-05 sa=2e-06 sb=2e-06
    Rd26 (Y4\#2312 Y4\#2313) resistor r=5.1795
    Rd36 (VDD!\#7 VDD!\#8) resistor r=99.34m
    Rd49 (VDD!\#5 VDD!\#2319) resistor r=4.4308
    Rc59 (VDD!\#5 VDD!\#7) resistor r=167.8m
    Rd19 (CK\#7 CK) resistor r=86.864
    Rd3 (Y4 Y4\#6) resistor r=1080.0958
    Rd24 (Y4 Y4\#2312) resistor r=2.5034
    Rc45 (Y4\#9 Y4\#2312) resistor r=3.4611
    Rc41 (Y4\#6 Y4\#2312) resistor r=93.0226
    Rs1 (10 VSS!) resistor r=50
    Rd23 (D\#2 D\#4) resistor r=1936.0317
    Rc42 (Y4\#9 Y4\#2310) resistor r=19.1845
    Rd1 (Y4\#2310 Y4\#2312) resistor r=3.3932
    Rd25 (Q\#2310 Q\#4) resistor r=2323.2666
    Rc46 (Q\#4 Q) resistor r=848.761
    Rc49 (Q\#2310 Q\#2311) resistor r=3600
    Rd18 (Q Q\#3) resistor r=554.3842
    Rc51 (Q\#4 Q\#3) resistor r=90859.5312
    Rd10 (SN\#2 SN\#4) resistor r=2536.0317
    Rc68 (SN\#2 SN) resistor r=86.364
    Rd9 (SN\#6 SN\#7) resistor r=2536.0317
    Rd8 (SN\#7 SN) resistor r=85.664
    Rc90 (QN\#2 QN\#8) resistor r=1668.4176
    Rc88 (QN\#2 QN\#3) resistor r=535.853
    Rc89 (QN\#3 QN\#6) resistor r=10.1
    Rc63 (VDD!\#27 VDD!\#2314) resistor r=111.4963
    Rd37 (VDD!\#2319 VDD!\#7) resistor r=6.6684
    Rd22 (CK\#6 CK\#7) resistor r=3136.0317
    Rc8 (VSS!\#3 VSS!\#9) resistor r=62.5645
    Rc23 (VSS!\#7 VSS!\#3) resistor r=5.1603
    Rc55 (CK\#7 CK\#8) resistor r=436.0318
    Rc40 (Y4\#6 Y4\#5) resistor r=1936.0317
    Rd28 (Y4\#2 Y4\#3) resistor r=1636.0317
    Rc43 (Y4\#2 Y4\#4) resistor r=1936.0317
    Rc44 (Y4\#2 Y4) resistor r=85.464
    Rd2 (Y4\#6 Y4\#8) resistor r=1036.0317
    Rd11 (Y2 Y2\#2311) resistor r=5.5331
    Rd44 (Y2\#2 Y2\#4) resistor r=736.0318
    Rc65 (Y2\#3 Y2\#2) resistor r=1959.2117
    Rc78 (Y2\#2 Y2) resistor r=85.464
    Rd46 (Y2\#2313 Y2\#2315) resistor r=2236.0317
    Rd31 (Y2\#2313 Y2\#2317) resistor r=91.564
    Rd45 (Y2\#2314 Y2\#2316) resistor r=736.0318
    Rc64 (Y2\#2313 Y2\#2314) resistor r=572.0635
    Rd17 (Q\#4 Q\#5) resistor r=5.1981
    Rd16 (Q\#5 Q\#6) resistor r=3.1952
    Rd4 (Y2\#3 Y2\#5) resistor r=781.9571
    Rc21 (Y1 Y1\#2) resistor r=10.1
    Rd42 (Y1\#2311 Y1) resistor r=614.2733
    Rc67 (Y2\#5 Y2\#6) resistor r=5.1779
    Rc9 (VSS! VSS!\#5) resistor r=266.3m
    Rc7 (VSS!\#3 VSS!\#5) resistor r=0.401
    Rc6 (VSS!\#9 VSS!\#5) resistor r=5.5851
    Rc54 (SN\#7 SN\#8) resistor r=1036.0317
    Rc16 (net3 net3\#2) resistor r=10.1
    Rc81 (QN\#4 QN\#5) resistor r=3600
    Rc87 (QN\#4 QN\#3) resistor r=1723.2665
    Rc82 (QN\#2 QN) resistor r=5.1
    Rc83 (QN\#2 QN\#7) resistor r=1701.7859
    Rc32 (net6 net6\#2) resistor r=10.1
    Rc85 (QN\#7 QN\#8) resistor r=5.0576
    Rc86 (VSS!\#5 VSS!\#2310) resistor r=5.0974
    Rc69 (CK\#2 CK\#3) resistor r=436.0318
    Rc10 (net9 net9\#2) resistor r=10.1779
    Rd7 (CK\#2 CK\#4) resistor r=3136.0317
    Rc70 (CK\#2 CK) resistor r=85.564
    Rd43 (Y1\#2310 Y1\#2311) resistor r=1172.0636
    Rc20 (Y1\#2311 Y1\#2312) resistor r=436.0318
    Rd53 (Y1\#2310 Y1\#4) resistor r=85.6621
    Rc2 (net7 net7\#2) resistor r=10.1
    Rc79 (SN\#2 SN\#3) resistor r=1036.0317
    Rc1 (net8 net8\#2) resistor r=10.1
    Rc26 (VSS! VSS!\#6) resistor r=5.1322
    Rc47 (Y1\#9 Y1\#2310) resistor r=1336.0317
    Rd32 (Y2\#2314 Y2\#8) resistor r=85.5621
    Rd33 (Y2\#8 Y2\#2310) resistor r=2.6545
    Rc33 (Y2 Y2\#8) resistor r=408.9m
    Rc4 (Y2\#8 Y2\#2311) resistor r=5.4796
    Rc25 (Y1\#4 Y1\#6) resistor r=3.3574
    Rd5 (VDD! VDD!\#2314) resistor r=2.8204
    Rd51 (Y1\#8 Y1\#6) resistor r=47.1422
    Rd52 (Y1\#4 Y1\#8) resistor r=3.1338
    Rc22 (Y1\#4 Y1\#7) resistor r=2.7545
    Rc71 (VDD! VDD!\#26) resistor r=2.6083
    Rc77 (VDD! VDD!\#27) resistor r=2.7535
    Rd14 (Y3\#2 Y3\#4) resistor r=736.0318
    Rc80 (Y2\#2319 Y2\#2317) resistor r=80.464
    Rd34 (Y2\#2319 Y2\#20) resistor r=2236.0317
    Rc66 (Y2\#2318 Y2\#2319) resistor r=1336.0317
    Rd15 (Y3\#2 Y3) resistor r=85.464
    Rc14 (Y3\#2 Y3\#3) resistor r=2836.0317
    Rc5 (VSS!\#3 VSS!\#8) resistor r=5.0974
    Rc74 (VDD!\#7 VDD!\#20) resistor r=2.6224
    Rc24 (VSS!\#1 VSS!\#7) resistor r=869.3669
    Rd20 (VDD!\#1 VDD!\#2315) resistor r=224.4252
    Rd38 (VDD!\#1 VDD!\#3) resistor r=2.7962
    Rc56 (D\#2 D\#3) resistor r=1036.0317
    Rd21 (D\#2 D) resistor r=85.564
    Rc39 (Y3 Y3\#2313) resistor r=4.0799
    Rc12 (Y3 Y3\#9) resistor r=301.5m
    Rc48 (Q\#5 Q\#9) resistor r=2.6545
    Rc50 (Q\#5 Q\#8) resistor r=3.2591
    Rc76 (VDD! VDD!\#2311) resistor r=99.84m
    Rc62 (VDD! VDD!\#25) resistor r=3.9666
    Rd13 (Y3\#2315 Y3\#2314) resistor r=736.0318
    Rc38 (Y3\#2315 Y3\#9) resistor r=92.1887
    Rd27 (Y3\#9 Y3\#2312) resistor r=2.6545
    Rd12 (Y3\#2315 Y3\#2311) resistor r=1247.4707
    Rd30 (Y3\#2311 Y3\#9) resistor r=2.8568
    Rc72 (VDD!\#3 VDD!\#2316) resistor r=2.6224
    Rd40 (VDD!\#3 VDD!\#2317) resistor r=5.3108
    Rd39 (VDD!\#2317 VDD!\#5) resistor r=5.3108
    Rc57 (VDD!\#2315 VDD!\#3) resistor r=2.6865
    Rc58 (VDD!\#3 VDD!\#5) resistor r=133.7m
    Rc73 (VDD!\#5 VDD!\#2318) resistor r=2.6224
    Rc52 (net1 net1\#2) resistor r=10.1
    Rd29 (Y3\#9 Y3\#2313) resistor r=8.1598
    Rc13 (Y3\#2316 Y3\#2315) resistor r=2236.0317
    Rc11 (Y3\#2316 Y3\#5) resistor r=476.9571
    Rc15 (Y3\#5 Y3\#6) resistor r=10.1779
    Rc37 (net12 net12\#2) resistor r=10.1779
    Rc3 (VSS!\#1 VSS!\#3) resistor r=5.5725
    Rc34 (net11 net11\#2) resistor r=10.1
    Rc19 (net4 net4\#2) resistor r=10.1
    Rc60 (VDD!\#8 VDD!\#21) resistor r=2.6224
    Rd41 (Q\#6 Q\#8) resistor r=23.2112
    Rc61 (VDD!\#2310 VDD!\#23) resistor r=2.6224
    Rc75 (VDD!\#8 VDD!\#2310) resistor r=167.8m
    Rd35 (VDD!\#8 VDD!\#22) resistor r=4.4308
    Rd47 (VDD!\#22 VDD!\#2310) resistor r=6.6684
    Rd48 (VDD!\#2310 VDD!\#2311) resistor r=66.01m
    Rd50 (VDD!\#2311 VDD!\#24) resistor r=2.6224
    Rd6 (VDD!\#2311 VDD!\#25) resistor r=7.9332
    MX40_M0_unmatched (Y1\#2 Y2\#3 net7 net7) nch w=2e-06 l=1e-06 as=0 \
        ad=5e-12 ps=0 pd=9e-06 sa=2e-06 sb=2e-06
    MX43_M0_unmatched (net3\#2 Y2\#2315 VSS!\#9 VSS!\#9) nch w=2e-06 \
        l=1e-06 as=0 ad=5e-12 ps=0 pd=9e-06 sa=2e-06 sb=2e-06
    MX46_M0_unmatched (QN\#6 Q\#2311 net6\#2 net6\#2) nch w=2e-06 l=1e-06 \
        as=0 ad=5e-12 ps=0 pd=9e-06 sa=2e-06 sb=2e-06
    MX42_M0_unmatched (net9 CK\#3 VSS!\#2310 VSS!\#2310) nch w=2e-06 \
        l=1e-06 as=0 ad=5e-12 ps=0 pd=9e-06 sa=2e-06 sb=2e-06
    MX41_M0_unmatched (Y2\#6 Y1\#2312 net9\#2 net9\#2) nch w=2e-06 l=1e-06 \
        as=0 ad=5e-12 ps=0 pd=9e-06 sa=2e-06 sb=2e-06
    MX39_M0_unmatched (net7\#2 Y4\#3 net8 net8) nch w=2e-06 l=1e-06 as=0 \
        ad=5e-12 ps=0 pd=9e-06 sa=2e-06 sb=2e-06
    MX38_M0_unmatched (net8\#2 SN\#3 VSS!\#6 VSS!\#6) nch w=2e-06 l=1e-06 \
        as=0 ad=5e-12 ps=0 pd=9e-06 sa=2e-06 sb=2e-06
    MX47_M0_unmatched (net6 Y3\#3 VSS!\#8 VSS!\#8) nch w=2e-06 l=1e-06 \
        as=0 ad=5e-12 ps=0 pd=9e-06 sa=2e-06 sb=2e-06
    MX48_M0_unmatched (net11\#2 Y2\#20 VSS!\#7 VSS!\#7) nch w=2e-06 \
        l=1e-06 as=0 ad=5e-12 ps=0 pd=9e-06 sa=2e-06 sb=2e-06
    MX45_M0_unmatched (Q\#3 QN\#4 net4 net4) nch w=2e-06 l=1e-06 as=0 \
        ad=5e-12 ps=0 pd=9e-06 sa=2e-06 sb=2e-06
    MX44_M0_unmatched (net4\#2 SN\#8 net3 net3) nch w=2e-06 l=1e-06 as=0 \
        ad=5e-12 ps=0 pd=9e-06 sa=2e-06 sb=2e-06
    MX52_M0_unmatched (net1 D\#3 VSS!\#1 VSS!\#1) nch w=2e-06 l=1e-06 as=0 \
        ad=5e-12 ps=0 pd=9e-06 sa=2e-06 sb=2e-06
    MX51_M0_unmatched (Y4\#2313 Y3\#2316 net1\#2 net1\#2) nch w=2e-06 \
        l=1e-06 as=0 ad=5e-12 ps=0 pd=9e-06 sa=2e-06 sb=2e-06
    MX50_M0_unmatched (Y3\#6 Y4\#8 net12 net12) nch w=2e-06 l=1e-06 as=0 \
        ad=5e-12 ps=0 pd=9e-06 sa=2e-06 sb=2e-06
    MX49_M0_unmatched (net12\#2 CK\#8 net11 net11) nch w=2e-06 l=1e-06 \
        as=0 ad=5e-12 ps=0 pd=9e-06 sa=2e-06 sb=2e-06
ends DFFSX1_analog_extracted
// End of subcircuit definition.

// Library name: KISTA_SOI_STDLIB2
// Cell name: INVX2
// View name: analog_extracted
subckt INVX2_analog_extracted Y A
    Rc3 (Y Y\#2) resistor r=1.575
    Rc2 (Y Y\#1) resistor r=2.775
    Rd1 (A\#2 A\#3) resistor r=1336.0317
    Rc4 (VDD! VDD!\#1) resistor r=1.4572
    Rd3 (A\#3 A) resistor r=85.564
    Rc1 (A\#3 A\#4) resistor r=1336.0317
    Rc5 (VSS! VSS!\#1) resistor r=2.6572
    Rs1 (1 VSS!) resistor r=50
    C3 (Y\#2 A\#2) capacitor c=368.289a
    C8 (VDD!\#1 Y\#2) capacitor c=208.188a
    C18 (VDD!\#1 A\#2) capacitor c=331.27a
    C2 (Y\#2 A) capacitor c=16.3017a
    C17 (VDD!\#1 A) capacitor c=9.15979e-18
    C1 (A Y) capacitor c=383.462a
    C4 (Y\#1 A) capacitor c=32.75a
    C5 (Y\#1 A\#4) capacitor c=260.339a
    C6 (A\#3 Y) capacitor c=24.1452a
    C9 (1 Y) capacitor c=2.08522e-15
    C10 (Y\#2 1) capacitor c=874.693a
    C12 (Y\#2 X0_5) capacitor c=606.836a
    C11 (Y\#1 1) capacitor c=1.28161e-15
    C19 (A\#3 VDD!\#1) capacitor c=5.80569e-19
    C20 (1 A) capacitor c=5.34718e-15
    C21 (A\#2 1) capacitor c=1.24923e-15
    C22 (A\#4 1) capacitor c=1.75231e-15
    C23 (A\#3 1) capacitor c=294.111a
    C24 (A\#2 X0_5) capacitor c=507.931a
    C28 (VDD!\#1 1) capacitor c=2.70265e-15
    C30 (VDD!\#1 X0_5) capacitor c=606.836a
    C29 (X0_5 VDD!) capacitor c=30.6619a
    C27 (1 VDD!) capacitor c=2.95818e-15
    C16 (A\#3 VSS!) capacitor c=1.20806e-19
    C13 (VSS! A) capacitor c=1.90599e-18
    C14 (VSS!\#1 A) capacitor c=18.9989a
    C7 (VSS!\#1 Y\#1) capacitor c=140.489a
    C15 (VSS!\#1 A\#4) capacitor c=223.286a
    C25 (1 VSS!) capacitor c=2.98884e-15
    C26 (VSS!\#1 1) capacitor c=3.01764e-15
    MX1_M0_unmatched (Y\#1 A\#4 VSS!\#1 VSS!\#1) nch w=4e-06 l=1e-06 as=0 \
        ad=1e-11 ps=0 pd=1.3e-05 sa=2e-06 sb=2e-06
    MX0_M0_unmatched (Y\#2 A\#2 VDD!\#1 VDD!\#1) pch w=8e-06 l=1e-06 as=0 \
        ad=2e-11 ps=0 pd=2.1e-05 sa=2e-06 sb=2e-06
ends INVX2_analog_extracted
// End of subcircuit definition.

// Library name: KISTA_SOI_STDLIB2
// Cell name: INVX3
// View name: analog_extracted
subckt INVX3_analog_extracted Y A
    Rc3 (Y Y\#2) resistor r=1.2083
    Rc2 (Y Y\#1) resistor r=1.8167
    Rd1 (A\#2 A\#3) resistor r=1336.0317
    Rc4 (VDD! VDD!\#1) resistor r=1.0905
    Rd3 (A\#3 A) resistor r=85.564
    Rc1 (A\#3 A\#4) resistor r=436.0318
    Rc5 (VSS! VSS!\#1) resistor r=1.8488
    Rs1 (1 VSS!) resistor r=50
    C3 (Y\#2 A\#2) capacitor c=476.307a
    C8 (VDD!\#1 Y\#2) capacitor c=275.887a
    C18 (VDD!\#1 A\#2) capacitor c=439.289a
    C2 (Y\#2 A) capacitor c=31.9608a
    C17 (VDD!\#1 A) capacitor c=19.5368a
    C1 (A Y) capacitor c=285.554a
    C4 (Y\#1 A) capacitor c=16.269a
    C5 (Y\#1 A\#4) capacitor c=210.235a
    C6 (A\#3 Y) capacitor c=17.9394a
    C9 (1 Y) capacitor c=1.37576e-15
    C10 (Y\#2 1) capacitor c=872.821a
    C12 (Y\#2 X0_5) capacitor c=805.086a
    C11 (Y\#1 1) capacitor c=673.164a
    C19 (1 A) capacitor c=4.2586e-15
    C20 (A\#2 1) capacitor c=1.24923e-15
    C21 (A\#4 1) capacitor c=756.045a
    C22 (A\#3 1) capacitor c=226.251a
    C23 (A\#2 X0_5) capacitor c=507.931a
    C28 (VDD!\#1 1) capacitor c=2.60395e-15
    C30 (VDD!\#1 X0_5) capacitor c=811.188a
    C29 (X0_5 VDD!) capacitor c=30.6619a
    C27 (1 VDD!) capacitor c=2.95818e-15
    C24 (VDD!\#1 VSS!) capacitor c=2.20488e-18
    C13 (VSS! A) capacitor c=2.07346e-18
    C25 (1 VSS!) capacitor c=2.98884e-15
    C14 (VSS!\#1 A) capacitor c=55.5924a
    C7 (VSS!\#1 Y\#1) capacitor c=174.338a
    C15 (VSS!\#1 A\#4) capacitor c=277.296a
    C16 (A\#3 VSS!\#1) capacitor c=3.655e-18
    C26 (VSS!\#1 1) capacitor c=3.11807e-15
    MX1_M0_unmatched (Y\#1 A\#4 VSS!\#1 VSS!\#1) nch w=6e-06 l=1e-06 as=0 \
        ad=1.5e-11 ps=0 pd=1.7e-05 sa=2e-06 sb=2e-06
    MX0_M0_unmatched (Y\#2 A\#2 VDD!\#1 VDD!\#1) pch w=1.2e-05 l=1e-06 \
        as=0 ad=3e-11 ps=0 pd=2.9e-05 sa=2e-06 sb=2e-06
ends INVX3_analog_extracted
// End of subcircuit definition.

// Library name: KISTA_SOI_STDLIB2
// Cell name: INVX4
// View name: analog_extracted
subckt INVX4_analog_extracted Y A
    C13 (Y\#2 VDD!\#1) capacitor c=345.276a
    C14 (VDD!\#1 A\#2) capacitor c=345.416a
    C19 (VDD!\#1 1) capacitor c=2.60272e-15
    C25 (Y\#2 A\#2) capacitor c=346.973a
    C32 (Y\#2 1) capacitor c=1.16072e-15
    C36 (A\#2 1) capacitor c=1.20836e-15
    C4 (A\#2 VSS!) capacitor c=6.64465e-18
    C9 (1 VSS!) capacitor c=2.7128e-15
    C1 (VDD!\#2 VSS!) capacitor c=9.06406e-18
    C20 (VDD!\#2 1) capacitor c=2.70084e-15
    C3 (A VSS!) capacitor c=2.08276e-18
    C15 (VDD!\#2 A) capacitor c=9.32361e-18
    C24 (Y\#2 A) capacitor c=78.3388a
    C35 (1 A) capacitor c=6.13543e-15
    C6 (VSS!\#2 A) capacitor c=18.9989a
    C11 (VSS!\#2 1) capacitor c=3.0133e-15
    C7 (VSS!\#2 A\#6) capacitor c=226.115a
    C28 (Y\#1 A\#6) capacitor c=245.351a
    C33 (Y\#1 1) capacitor c=509.081a
    C39 (A\#6 1) capacitor c=1.73224e-15
    C17 (A\#4 VDD!\#2) capacitor c=4.16748e-19
    C41 (A\#4 1) capacitor c=242.735a
    C23 (A Y) capacitor c=730.722a
    C30 (A\#4 Y) capacitor c=33.8577a
    C31 (1 Y) capacitor c=1.29892e-15
    C29 (A\#3 Y) capacitor c=722.67a
    C8 (A\#3 VSS!) capacitor c=5.59618e-20
    C40 (A\#3 1) capacitor c=3.94195e-15
    C42 (A\#2 2) capacitor c=481.439a
    C12 (2 VSS!) capacitor c=3.06619e-20
    C2 (Y\#1 VSS!\#1) capacitor c=209.878a
    C10 (VSS!\#1 1) capacitor c=3.01984e-15
    C21 (VDD!\#1 2) capacitor c=610.327a
    C18 (1 VDD!) capacitor c=2.7128e-15
    C22 (VDD!\#2 2) capacitor c=604.287a
    C34 (Y\#2 2) capacitor c=162.938a
    C43 (A\#7 2) capacitor c=509.812a
    C16 (VDD!\#2 A\#7) capacitor c=335.469a
    C26 (Y\#2 A\#7) capacitor c=346.973a
    C37 (A\#7 1) capacitor c=1.236e-15
    C38 (A\#5 1) capacitor c=1.58815e-15
    C5 (VSS!\#1 A\#5) capacitor c=242.706a
    C27 (Y\#1 A\#5) capacitor c=244.666a
    MX2_M0_unmatched (Y\#1 A\#6 VSS!\#2 VSS!\#2) nch w=4e-06 l=1e-06 \
        as=1.2e-11 ad=0 ps=1.4e-05 pd=0 sa=2e-06 sb=2e-06
    MX3_M0_unmatched (Y\#1 A\#5 VSS!\#1 VSS!\#1) nch w=4e-06 l=1e-06 \
        as=1.2e-11 ad=0 ps=1.4e-05 pd=0 sa=2e-06 sb=2e-06
    Rs1 (1 VSS!) resistor r=50
    Rc7 (VSS! VSS!\#2) resistor r=2.6572
    Rd5 (A\#4 A\#6) resistor r=1327.5659
    Rd3 (A\#4 A) resistor r=119.1987
    Rc3 (Y Y\#2) resistor r=1.675
    Rc2 (Y Y\#1) resistor r=2.675
    Rd1 (A\#2 A\#3) resistor r=1336.0317
    Rc6 (VSS!\#1 VSS!) resistor r=2.6632
    Rc4 (VDD!\#1 VDD!) resistor r=1.4632
    Rc5 (VDD! VDD!\#2) resistor r=1.4572
    Rd6 (A\#4 A\#7) resistor r=1327.5659
    Rd4 (A\#3 A\#4) resistor r=258.7097
    Rc1 (A\#3 A\#5) resistor r=1336.0317
    MX1_M0_unmatched (Y\#2 A\#2 VDD!\#1 VDD!\#1) pch w=8e-06 l=1e-06 \
        as=2.4e-11 ad=0 ps=2.2e-05 pd=0 sa=2e-06 sb=2e-06
    MX0_M0_unmatched (Y\#2 A\#7 VDD!\#2 VDD!\#2) pch w=8e-06 l=1e-06 \
        as=2.4e-11 ad=0 ps=2.2e-05 pd=0 sa=2e-06 sb=2e-06
ends INVX4_analog_extracted
// End of subcircuit definition.

// Library name: KISTA_SOI_STDLIB2
// Cell name: NAND2X2
// View name: analog_extracted
subckt NAND2X2_analog_extracted A Y B
    Rs1 (3 VSS!) resistor r=50
    Rc10 (VSS!\#1 VSS!) resistor r=2.6117
    Rd1 (A\#2 A\#3) resistor r=1336.0317
    Rd3 (A\#3 A) resistor r=85.5515
    Rc1 (A\#3 A\#4) resistor r=1336.0317
    Rd2 (Y Y\#1) resistor r=2.0043
    Rc4 (Y\#1 Y\#3) resistor r=6.7095
    Rd4 (Y Y\#3) resistor r=2.0444
    Rc6 (Y Y\#4) resistor r=2.775
    Rc7 (B\#2 B\#3) resistor r=1936.0317
    Rc8 (VDD!\#1 VDD!) resistor r=1.5298
    Rc9 (VDD! VDD!\#2) resistor r=1.4222
    Rc5 (B\#3 B) resistor r=85.5515
    Rd6 (B\#3 B\#4) resistor r=736.0318
    Rc3 (net1 net1\#2) resistor r=5.05
    C20 (VDD!\#1 B\#2) capacitor c=329.14a
    C22 (VDD!\#1 3) capacitor c=4.51168e-15
    C52 (B\#2 3) capacitor c=1.74469e-15
    C9 (B\#2 VSS!) capacitor c=10.2785a
    C12 (3 VSS!) capacitor c=9.944e-15
    C1 (VDD!\#2 VSS!) capacitor c=8.13978e-18
    C23 (VDD!\#2 3) capacitor c=55.9556a
    C2 (A VSS!) capacitor c=6.86949e-18
    C17 (VDD!\#2 A) capacitor c=20.8059a
    C33 (3 A) capacitor c=5.66071e-15
    C3 (A\#2 VSS!) capacitor c=2.98108e-18
    C18 (VDD!\#2 A\#2) capacitor c=347.812a
    C34 (A\#2 3) capacitor c=1.32208e-15
    C4 (VSS!\#1 A) capacitor c=7.37888e-18
    C13 (VSS!\#1 3) capacitor c=556.668a
    C5 (VSS!\#1 A\#4) capacitor c=226.383a
    C35 (A\#4 3) capacitor c=1.76664e-15
    C6 (A\#3 VSS!\#1) capacitor c=7.60317e-19
    C36 (A\#3 3) capacitor c=309.853a
    C7 (Y\#4 VSS!) capacitor c=78.9086a
    C46 (Y\#4 3) capacitor c=1.40024e-15
    C8 (B VSS!) capacitor c=17.5633a
    C31 (B A) capacitor c=78.6876a
    C32 (A\#3 B) capacitor c=4.97518e-18
    C30 (A\#3 Y) capacitor c=8.00979e-19
    C27 (Y A) capacitor c=7.47179e-18
    C28 (Y\#3 A) capacitor c=15.5499a
    C19 (Y\#3 VDD!\#1) capacitor c=474.892a
    C29 (Y\#3 A\#2) capacitor c=261.383a
    C39 (B Y) capacitor c=270.541a
    C40 (B\#2 Y) capacitor c=859.476a
    C41 (Y\#4 B) capacitor c=98.7158a
    C43 (Y\#3 B) capacitor c=14.2056a
    C45 (3 Y) capacitor c=2.53016e-15
    C47 (Y\#3 3) capacitor c=1.50802e-15
    C51 (3 B) capacitor c=5.27704e-15
    C44 (B\#3 Y) capacitor c=24.2452a
    C11 (B\#3 VSS!) capacitor c=9.34292e-19
    C54 (B\#3 3) capacitor c=286.49a
    C59 (B\#2 X3_5) capacitor c=509.926a
    C24 (VDD!\#1 X3_5) capacitor c=646.972a
    C49 (Y\#3 X3_5) capacitor c=711.262a
    C21 (3 VDD!) capacitor c=5.60056e-15
    C25 (X2_5 VDD!) capacitor c=30.6619a
    C26 (VDD!\#2 X2_5) capacitor c=646.972a
    C38 (A\#2 X2_5) capacitor c=504.33a
    C50 (Y\#3 X2_5) capacitor c=569.178a
    C10 (B\#4 VSS!) capacitor c=49.7984a
    C42 (Y\#4 B\#4) capacitor c=190.93a
    C53 (B\#4 3) capacitor c=1.0921e-15
    C58 (B\#3 net1) capacitor c=1.72332e-18
    C14 (net1 VSS!) capacitor c=80.4539a
    C15 (net1\#2 VSS!) capacitor c=68.6314a
    C16 (VSS!\#1 net1\#2) capacitor c=75.9625a
    C37 (net1\#2 A\#4) capacitor c=139.36a
    C48 (Y\#4 net1) capacitor c=82.8682a
    C56 (B\#4 net1) capacitor c=139.36a
    C55 (net1 B) capacitor c=25.517a
    C57 (net1\#2 B) capacitor c=22.1965a
    C60 (net1 3) capacitor c=393.336a
    C61 (net1\#2 3) capacitor c=393.678a
    MX4_M0_unmatched (net1\#2 A\#4 VSS!\#1 VSS!\#1) nch w=4e-06 l=1e-06 \
        as=0 ad=1e-11 ps=0 pd=1.3e-05 sa=2e-06 sb=2e-06
    MX5_M0_unmatched (Y\#4 B\#4 net1 net1) nch w=4e-06 l=1e-06 as=0 \
        ad=1e-11 ps=0 pd=1.3e-05 sa=2e-06 sb=2e-06
    MX3_M0_unmatched (Y\#1 B\#2 VDD!\#1 VDD!\#1) pch w=8e-06 l=1e-06 as=0 \
        ad=2e-11 ps=0 pd=2.1e-05 sa=2e-06 sb=2e-06
    MX2_M0_unmatched (Y\#3 A\#2 VDD!\#2 VDD!\#2) pch w=8e-06 l=1e-06 as=0 \
        ad=2e-11 ps=0 pd=2.1e-05 sa=2e-06 sb=2e-06
ends NAND2X2_analog_extracted
// End of subcircuit definition.

// Library name: KISTA_SOI_STDLIB2
// Cell name: NAND2X3
// View name: analog_extracted
subckt NAND2X3_analog_extracted Y A B
    Rd10 (VDD! VDD!\#4) resistor r=1.8488
    Rd8 (VDD! VDD!\#3) resistor r=0.033
    Rs1 (3 VSS!) resistor r=50
    Rd6 (Y Y\#3) resistor r=1.9167
    Rc15 (Y Y\#4) resistor r=2.1862
    Rd9 (Y\#4 Y\#2) resistor r=22.8911
    Rc13 (Y Y\#2) resistor r=2.4986
    Rd1 (A\#4 A\#5) resistor r=219.2584
    Rc1 (A\#5 A\#6) resistor r=697.4454
    Rc16 (VDD!\#1 VDD!\#5) resistor r=108.5171
    Rc5 (VDD!\#3 VDD!\#6) resistor r=1.8141
    Rd2 (A\#5 A\#7) resistor r=2005.2902
    Rd4 (A\#7 A) resistor r=85.5671
    Rc3 (A\#7 A\#8) resistor r=436.0318
    Rd7 (VDD!\#1 VDD!\#3) resistor r=1.9545
    Rc12 (VDD!\#5 VDD!\#3) resistor r=1.8781
    Rc4 (B\#2 B\#3) resistor r=697.4454
    Rd5 (B\#3 B\#5) resistor r=219.2584
    Rc14 (B\#3 B\#4) resistor r=1405.2902
    Rc17 (VSS!\#1 VSS!) resistor r=1.8011
    Rc11 (B\#4 B) resistor r=85.5515
    Rd3 (B\#4 B\#6) resistor r=1036.0317
    Rc6 (net1 net1\#2) resistor r=3.3667
    C13 (Y\#4 B\#2) capacitor c=354.41a
    C20 (Y\#4 3) capacitor c=44.4317a
    C48 (B\#2 VSS!) capacitor c=5.48879e-18
    C53 (3 VSS!) capacitor c=14.6577f
    C58 (VDD!\#1 B\#2) capacitor c=288.123a
    C64 (B\#2 3) capacitor c=884.097a
    C7 (Y\#3 VSS!) capacitor c=90.3805a
    C19 (Y\#3 3) capacitor c=1.29107e-15
    C2 (Y\#3 A) capacitor c=2.50265e-18
    C25 (VSS! A) capacitor c=16.4049a
    C35 (3 A) capacitor c=5.53165e-15
    C1 (A Y) capacitor c=3.1415e-18
    C18 (3 Y) capacitor c=4.10173e-15
    C3 (Y\#2 A) capacitor c=3.45455e-18
    C21 (Y\#2 3) capacitor c=1.16218e-15
    C4 (Y\#2 A\#4) capacitor c=181.758a
    C26 (A\#4 VSS!) capacitor c=6.49196e-18
    C36 (A\#4 3) capacitor c=172.648a
    C5 (Y\#2 A\#6) capacitor c=345.718a
    C27 (A\#6 VSS!) capacitor c=5.20207e-18
    C37 (A\#6 3) capacitor c=877.216a
    C6 (A\#5 Y\#2) capacitor c=914.982a
    C30 (A\#5 VSS!) capacitor c=7.57749e-19
    C39 (A\#5 3) capacitor c=2.75792e-15
    C8 (VDD!\#5 Y\#4) capacitor c=330.575a
    C46 (VDD!\#5 VSS!) capacitor c=27.394a
    C9 (VDD!\#6 Y\#2) capacitor c=321.398a
    C31 (VDD!\#6 A\#4) capacitor c=292.996a
    C42 (A\#4 4) capacitor c=402.854a
    C22 (Y\#2 4) capacitor c=192.279a
    C41 (4 A) capacitor c=5.70334e-18
    C43 (A\#6 4) capacitor c=504.372a
    C44 (A\#5 4) capacitor c=93.6272a
    C61 (VDD!\#4 4) capacitor c=673.968a
    C32 (VDD!\#4 A\#6) capacitor c=272.388a
    C15 (Y\#2 B) capacitor c=7.3688e-18
    C10 (B Y) capacitor c=342.877a
    C11 (Y\#3 B) capacitor c=16.2556a
    C33 (B A) capacitor c=100.314a
    C34 (A\#7 B) capacitor c=1.21044e-19
    C40 (A\#7 3) capacitor c=5.56109e-18
    C47 (B VSS!) capacitor c=4.72288e-18
    C60 (VDD!\#3 3) capacitor c=14.8883f
    C63 (3 B) capacitor c=5.16312e-15
    C28 (VSS!\#1 A) capacitor c=62.8307a
    C29 (VSS!\#1 A\#8) capacitor c=278.743a
    C38 (A\#8 3) capacitor c=752.34a
    C54 (VSS!\#1 3) capacitor c=591.353a
    C62 (VDD!\#1 7) capacitor c=828.118a
    C23 (Y\#4 7) capacitor c=192.279a
    C69 (B\#2 7) capacitor c=476.932a
    C16 (B\#3 Y) capacitor c=937.052a
    C17 (B\#4 Y) capacitor c=22.7069a
    C51 (B\#3 VSS!) capacitor c=1.05426e-18
    C52 (B\#4 VSS!) capacitor c=1.43353e-19
    C67 (B\#3 3) capacitor c=2.06216e-15
    C68 (B\#4 3) capacitor c=277.203a
    C71 (B\#3 7) capacitor c=94.2651a
    C70 (B\#5 7) capacitor c=420.839a
    C14 (Y\#4 B\#5) capacitor c=181.791a
    C59 (VDD!\#5 B\#5) capacitor c=293.028a
    C49 (B\#5 VSS!) capacitor c=6.49196e-18
    C65 (B\#5 3) capacitor c=172.626a
    C12 (Y\#3 B\#6) capacitor c=279.61a
    C50 (B\#6 VSS!) capacitor c=70.031a
    C66 (B\#6 3) capacitor c=1.44845e-15
    C75 (B\#4 net1) capacitor c=8.64792e-19
    C24 (Y\#3 net1) capacitor c=119.699a
    C73 (B\#6 net1) capacitor c=195.104a
    C55 (net1 VSS!) capacitor c=78.2692a
    C56 (net1\#2 VSS!) capacitor c=70.7811a
    C45 (net1\#2 A\#8) capacitor c=195.104a
    C57 (VSS!\#1 net1\#2) capacitor c=112.793a
    C72 (net1 B) capacitor c=13.6776a
    C74 (net1\#2 B) capacitor c=9.71357e-18
    C76 (net1 3) capacitor c=619.006a
    C77 (net1\#2 3) capacitor c=557.239a
    MX7_M0_unmatched (Y\#3 B\#6 net1 net1) nch w=6e-06 l=1e-06 as=0 \
        ad=1.5e-11 ps=0 pd=1.7e-05 sa=2e-06 sb=2e-06
    MX6_M0_unmatched (net1\#2 A\#8 VSS!\#1 VSS!\#1) nch w=6e-06 l=1e-06 \
        as=0 ad=1.5e-11 ps=0 pd=1.7e-05 sa=2e-06 sb=2e-06
    MX5_M0_unmatched (Y\#4 B\#2 VDD!\#1 VDD!\#1) pch w=6e-06 l=1e-06 \
        as=1.8e-11 ad=0 ps=1.8e-05 pd=0 sa=2e-06 sb=2e-06
    MX3_M0_unmatched (Y\#2 A\#4 VDD!\#6 VDD!\#6) pch w=6e-06 l=1e-06 \
        as=1.8e-11 ad=0 ps=1.8e-05 pd=0 sa=2e-06 sb=2e-06
    MX2_M0_unmatched (Y\#2 A\#6 VDD!\#4 VDD!\#4) pch w=6e-06 l=1e-06 \
        as=1.8e-11 ad=0 ps=1.8e-05 pd=0 sa=2e-06 sb=2e-06
    MX4_M0_unmatched (Y\#4 B\#5 VDD!\#5 VDD!\#5) pch w=6e-06 l=1e-06 \
        as=1.8e-11 ad=0 ps=1.8e-05 pd=0 sa=2e-06 sb=2e-06
ends NAND2X3_analog_extracted
// End of subcircuit definition.

// Library name: KISTA_SOI_STDLIB2
// Cell name: NAND3X1
// View name: analog_extracted
subckt NAND3X1_analog_extracted Y C A B
    C9 (VDD!\#1 Y\#5) capacitor c=169.244a
    C22 (C\#2 VSS!) capacitor c=6.13654e-18
    C25 (VDD!\#1 C\#2) capacitor c=235.866a
    C31 (C\#2 4) capacitor c=2.41652e-15
    C48 (4 VSS!) capacitor c=14.4681f
    C69 (VDD!\#1 4) capacitor c=5.66442e-15
    C4 (Y\#2 C\#2) capacitor c=869.502a
    C15 (Y\#2 4) capacitor c=10.1992f
    C5 (Y\#4 VSS!) capacitor c=100.056a
    C2 (Y\#4 C\#4) capacitor c=168.949a
    C23 (C\#4 VSS!) capacitor c=67.5166a
    C32 (C\#4 4) capacitor c=1.42514e-15
    C13 (Y\#2 B) capacitor c=16.0854a
    C44 (B VSS!) capacitor c=14.8914a
    C76 (4 B) capacitor c=6.8298e-15
    C14 (Y\#2 B\#2) capacitor c=821.295a
    C45 (B\#2 VSS!) capacitor c=14.7847a
    C77 (B\#2 4) capacitor c=2.45053e-15
    C16 (Y\#4 net3) capacitor c=46.0379a
    C35 (C\#4 net3) capacitor c=83.616a
    C53 (net3 VSS!) capacitor c=73.0066a
    C87 (net3 4) capacitor c=236.848a
    C3 (C\#3 Y) capacitor c=30.6382a
    C24 (C\#3 VSS!) capacitor c=3.09066e-19
    C28 (C\#3 B) capacitor c=1.32925e-18
    C33 (C\#3 4) capacitor c=356.597a
    C36 (C\#3 net3) capacitor c=1.09427e-19
    C37 (C\#2 X5_5) capacitor c=508.173a
    C18 (Y\#5 X5_5) capacitor c=406.72a
    C72 (VDD!\#1 X5_5) capacitor c=181.705a
    C1 (C Y) capacitor c=534.153a
    C12 (B\#3 Y) capacitor c=3.47772e-19
    C21 (VSS! C) capacitor c=13.8513a
    C26 (B C) capacitor c=20.9718a
    C27 (B\#3 C) capacitor c=1.32925e-18
    C29 (C\#3 B\#3) capacitor c=8.42507e-20
    C30 (4 C) capacitor c=6.33644e-15
    C34 (net3 C) capacitor c=46.786a
    C17 (Y\#2 net3\#2) capacitor c=1.56407e-18
    C47 (B\#3 VSS!) capacitor c=6.58406e-19
    C54 (net3\#2 VSS!) capacitor c=73.7811a
    C79 (B\#3 4) capacitor c=373.397a
    C88 (net3\#2 4) capacitor c=238.004a
    C38 (A VSS!) capacitor c=6.44656e-18
    C57 (B A) capacitor c=14.9767a
    C59 (B\#3 A) capacitor c=4.30674e-19
    C61 (4 A) capacitor c=6.66157e-15
    C6 (Y\#3 A) capacitor c=134.368a
    C7 (Y\#3 A\#2) capacitor c=258.561a
    C39 (A\#2 VSS!) capacitor c=9.56069e-18
    C62 (A\#2 4) capacitor c=1.26397e-15
    C8 (A\#3 Y\#3) capacitor c=4.94174e-18
    C42 (A\#3 VSS!) capacitor c=5.48353e-19
    C58 (A\#3 B) capacitor c=9.4926e-19
    C80 (net4 B) capacitor c=12.1712a
    C50 (net4 VSS!) capacitor c=74.1313a
    C60 (B\#3 A\#3) capacitor c=2.72971e-20
    C64 (A\#3 4) capacitor c=378.269a
    C82 (B\#3 net4) capacitor c=7.71439e-19
    C46 (B\#4 VSS!) capacitor c=74.3598a
    C78 (B\#4 4) capacitor c=1.45605e-15
    C81 (B\#4 net4) capacitor c=83.616a
    C83 (net3\#2 B\#4) capacitor c=83.616a
    C89 (net3\#2 net4) capacitor c=39.8112a
    C85 (net4 4) capacitor c=299.333a
    C51 (net4\#2 VSS!) capacitor c=66.4358a
    C86 (net4\#2 4) capacitor c=238.004a
    C63 (A\#4 4) capacitor c=2.78859e-15
    C65 (net4\#2 A\#4) capacitor c=83.616a
    C10 (VDD!\#4 Y\#6) capacitor c=201.232a
    C43 (VDD!\#4 VSS!) capacitor c=20.2528a
    C40 (VSS!\#1 A) capacitor c=3.00175e-18
    C55 (VDD!\#3 A) capacitor c=19.3507a
    C11 (VDD!\#3 Y\#3) capacitor c=178.905a
    C41 (VSS!\#1 A\#4) capacitor c=174.224a
    C52 (VSS!\#1 net4\#2) capacitor c=39.1322a
    C49 (VSS!\#1 4) capacitor c=527.615a
    C56 (VDD!\#3 A\#2) capacitor c=238.688a
    C67 (VDD!\#4 B\#2) capacitor c=234.793a
    C70 (VDD!\#4 4) capacitor c=36.9004a
    C71 (VDD!\#3 4) capacitor c=45.4304a
    C68 (4 VDD!) capacitor c=9.036e-15
    C74 (X3_5 VDD!) capacitor c=30.6619a
    C20 (Y\#3 X3_5) capacitor c=181.705a
    C66 (A\#2 X3_5) capacitor c=531.582a
    C75 (VDD!\#3 X3_5) capacitor c=406.72a
    C19 (Y\#6 X4_5) capacitor c=148.996a
    C73 (VDD!\#4 X4_5) capacitor c=148.996a
    C84 (B\#2 X4_5) capacitor c=531.824a
    MX5_M0_unmatched (Y\#5 C\#2 VDD!\#1 VDD!\#1) pch w=4e-06 l=1e-06 as=0 \
        ad=1e-11 ps=0 pd=1.3e-05 sa=2e-06 sb=2e-06
    MX3_M0_unmatched (Y\#3 A\#2 VDD!\#3 VDD!\#3) pch w=4e-06 l=1e-06 as=0 \
        ad=1e-11 ps=0 pd=1.3e-05 sa=2e-06 sb=2e-06
    MX4_M0_unmatched (Y\#6 B\#2 VDD!\#4 VDD!\#4) pch w=4e-06 l=1e-06 as=0 \
        ad=1e-11 ps=0 pd=1.3e-05 sa=2e-06 sb=2e-06
    Rs1 (4 VSS!) resistor r=50
    Rd5 (Y\#5 Y\#2) resistor r=5.2478
    Rc9 (C\#3 C\#4) resistor r=1036.0317
    Rc4 (Y Y\#4) resistor r=5.3
    Rd7 (C\#2 C\#3) resistor r=2536.0317
    Rd6 (Y Y\#5) resistor r=5.8521
    Rc1 (Y Y\#2) resistor r=388.9m
    Rd9 (C\#3 C) resistor r=85.564
    Rc5 (net3 net3\#2) resistor r=10.1
    Rd2 (B\#2 B\#3) resistor r=2536.0317
    Rd4 (B\#3 B) resistor r=85.564
    Rc13 (Y\#2 Y\#3) resistor r=2.851
    Rc14 (Y\#2 Y\#6) resistor r=2.6545
    Rc7 (B\#3 B\#4) resistor r=1036.0317
    Rc3 (net4 net4\#2) resistor r=10.1
    Rc6 (A\#2 A\#3) resistor r=1336.0317
    Rc10 (A\#3 A) resistor r=85.564
    Rd8 (A\#3 A\#4) resistor r=2236.0317
    Rc16 (VSS!\#1 VSS!) resistor r=5.0854
    Rd1 (VDD! VDD!\#3) resistor r=2.6222
    Rd3 (VDD!\#1 VDD!\#4) resistor r=111.9025
    Rc11 (VDD! VDD!\#1) resistor r=2.8307
    Rc8 (VDD! VDD!\#4) resistor r=2.7532
    MX8_M0_unmatched (Y\#4 C\#4 net3 net3) nch w=2e-06 l=1e-06 as=0 \
        ad=5e-12 ps=0 pd=9e-06 sa=2e-06 sb=2e-06
    MX7_M0_unmatched (net3\#2 B\#4 net4 net4) nch w=2e-06 l=1e-06 as=0 \
        ad=5e-12 ps=0 pd=9e-06 sa=2e-06 sb=2e-06
    MX6_M0_unmatched (net4\#2 A\#4 VSS!\#1 VSS!\#1) nch w=2e-06 l=1e-06 \
        as=0 ad=5e-12 ps=0 pd=9e-06 sa=2e-06 sb=2e-06
ends NAND3X1_analog_extracted
// End of subcircuit definition.

// Library name: KISTA_SOI_STDLIB2
// Cell name: NAND4X1
// View name: analog_extracted
subckt NAND4X1_analog_extracted C D Y A B
    C2 (VDD!\#1 D\#2) capacitor c=235.866a
    C3 (VDD!\#1 Y\#6) capacitor c=169.244a
    C45 (D\#2 VSS!) capacitor c=6.06615e-18
    C49 (D\#2 5) capacitor c=2.45402e-15
    C87 (5 VSS!) capacitor c=18.9538f
    C10 (VDD!\#5 VSS!) capacitor c=29.1464a
    C1 (VDD!\#5 C\#2) capacitor c=234.793a
    C25 (C\#2 VSS!) capacitor c=15.6154a
    C33 (C\#2 5) capacitor c=1.81534e-15
    C4 (VDD!\#5 Y\#7) capacitor c=201.224a
    C12 (VDD!\#2 5) capacitor c=19.3813f
    C13 (VDD!\#1 X7_5) capacitor c=181.705a
    C55 (D\#2 X7_5) capacitor c=508.173a
    C66 (Y\#6 X7_5) capacitor c=406.72a
    C14 (VDD!\#5 X6_5) capacitor c=148.996a
    C39 (C\#2 X6_5) capacitor c=531.824a
    C67 (Y\#7 X6_5) capacitor c=148.996a
    C22 (Y\#2 C\#2) capacitor c=746.262a
    C23 (Y\#2 C\#3) capacitor c=3.31278e-18
    C27 (C\#3 VSS!) capacitor c=1.00755e-19
    C35 (C\#3 5) capacitor c=371.173a
    C63 (Y\#2 5) capacitor c=12.0193f
    C41 (D\#2 Y) capacitor c=869.534a
    C20 (D\#3 C\#3) capacitor c=3.54303e-20
    C43 (D\#3 Y) capacitor c=30.5012a
    C47 (D\#3 VSS!) capacitor c=4.1944e-19
    C51 (D\#3 5) capacitor c=356.998a
    C18 (C\#3 D) capacitor c=5.58993e-19
    C40 (Y D) capacitor c=531.992a
    C44 (VSS! D) capacitor c=15.7885a
    C48 (5 D) capacitor c=6.34278e-15
    C59 (Y\#5 VSS!) capacitor c=111.524a
    C17 (D C) capacitor c=20.5372a
    C52 (net2 D) capacitor c=46.786a
    C19 (D\#3 C) capacitor c=1.3017e-18
    C21 (Y\#2 C) capacitor c=52.2666a
    C24 (VSS! C) capacitor c=11.036a
    C32 (5 C) capacitor c=6.61196e-15
    C54 (D\#3 net2) capacitor c=1.09427e-19
    C42 (Y\#5 D\#4) capacitor c=168.949a
    C46 (D\#4 VSS!) capacitor c=67.4808a
    C50 (D\#4 5) capacitor c=1.42516e-15
    C53 (D\#4 net2) capacitor c=83.616a
    C64 (Y\#5 net2) capacitor c=46.0379a
    C94 (net2 VSS!) capacitor c=73.0066a
    C110 (net2 5) capacitor c=236.848a
    C65 (Y\#2 net2\#2) capacitor c=1.56407e-18
    C95 (net2\#2 VSS!) capacitor c=73.7811a
    C111 (net2\#2 5) capacitor c=238.004a
    C26 (C\#4 VSS!) capacitor c=80.4468a
    C34 (C\#4 5) capacitor c=2.16246e-15
    C38 (net2\#2 C\#4) capacitor c=83.616a
    C28 (B C) capacitor c=58.3087a
    C30 (C\#3 B) capacitor c=3.69574e-18
    C31 (C\#3 B\#2) capacitor c=1.63731e-18
    C29 (B\#2 C) capacitor c=25.8323a
    C36 (net3 C) capacitor c=9.12576e-18
    C37 (C\#4 net3) capacitor c=83.616a
    C113 (net2\#2 net3) capacitor c=39.8112a
    C60 (Y\#2 B) capacitor c=19.8732a
    C62 (Y\#2 B\#2) capacitor c=7.25281e-19
    C83 (B VSS!) capacitor c=1.45151e-18
    C86 (B\#2 VSS!) capacitor c=17.0874a
    C92 (net3 VSS!) capacitor c=74.1313a
    C96 (5 B) capacitor c=978.273a
    C99 (B\#2 5) capacitor c=5.81638e-15
    C108 (net3 5) capacitor c=237.178a
    C93 (net3\#2 VSS!) capacitor c=74.1524a
    C102 (net3\#2 B) capacitor c=2.7505e-18
    C104 (B\#2 net3\#2) capacitor c=1.21532e-18
    C109 (net3\#2 5) capacitor c=366.89a
    C61 (Y\#2 B\#4) capacitor c=841.707a
    C84 (B\#4 VSS!) capacitor c=12.2332a
    C97 (B\#4 5) capacitor c=1.81549e-15
    C85 (B\#3 VSS!) capacitor c=66.6751a
    C98 (B\#3 5) capacitor c=2.07934e-15
    C103 (net3\#2 B\#3) capacitor c=83.616a
    C11 (VDD!\#6 B\#4) capacitor c=234.793a
    C5 (VDD!\#6 Y\#8) capacitor c=204.107a
    C6 (VDD!\#4 Y\#4) capacitor c=178.905a
    C15 (VDD!\#6 X5_5) capacitor c=148.996a
    C68 (Y\#8 X5_5) capacitor c=148.996a
    C105 (B\#4 X5_5) capacitor c=531.824a
    C7 (VDD!\#4 A) capacitor c=21.508a
    C56 (Y\#4 A) capacitor c=206.03a
    C70 (VSS! A) capacitor c=5.89847e-18
    C75 (B A) capacitor c=10.6023a
    C77 (5 A) capacitor c=6.51741e-15
    C8 (VDD!\#4 A\#2) capacitor c=238.688a
    C57 (Y\#4 A\#2) capacitor c=189.689a
    C71 (A\#2 VSS!) capacitor c=8.51527e-18
    C78 (A\#2 5) capacitor c=599.791a
    C9 (A\#3 VDD!\#4) capacitor c=1.36323e-18
    C16 (VDD!\#4 X4_5) capacitor c=437.382a
    C58 (A\#3 Y\#4) capacitor c=13.0587a
    C69 (Y\#4 X4_5) capacitor c=181.705a
    C82 (A\#2 X4_5) capacitor c=531.582a
    C74 (A\#3 VSS!) capacitor c=1.92715e-19
    C76 (A\#3 B) capacitor c=6.72e-19
    C100 (net4 B) capacitor c=2.9388e-18
    C80 (A\#3 5) capacitor c=359.359a
    C89 (net4 VSS!) capacitor c=74.1313a
    C101 (B\#3 net4) capacitor c=83.616a
    C112 (net3\#2 net4) capacitor c=39.8112a
    C106 (net4 5) capacitor c=237.766a
    C90 (net4\#2 VSS!) capacitor c=66.4358a
    C72 (VSS!\#1 A) capacitor c=2.20122e-18
    C73 (VSS!\#1 A\#4) capacitor c=170.544a
    C79 (A\#4 5) capacitor c=3.47533e-15
    C81 (net4\#2 A\#4) capacitor c=83.616a
    C88 (VSS!\#1 5) capacitor c=392.727a
    C91 (VSS!\#1 net4\#2) capacitor c=39.1322a
    C107 (net4\#2 5) capacitor c=238.004a
    MX11_M0_unmatched (Y\#5 D\#4 net2 net2) nch w=2e-06 l=1e-06 as=0 \
        ad=5e-12 ps=0 pd=9e-06 sa=2e-06 sb=2e-06
    MX10_M0_unmatched (net2\#2 C\#4 net3 net3) nch w=2e-06 l=1e-06 as=0 \
        ad=5e-12 ps=0 pd=9e-06 sa=2e-06 sb=2e-06
    MX9_M0_unmatched (net3\#2 B\#3 net4 net4) nch w=2e-06 l=1e-06 as=0 \
        ad=5e-12 ps=0 pd=9e-06 sa=2e-06 sb=2e-06
    MX8_M0_unmatched (net4\#2 A\#4 VSS!\#1 VSS!\#1) nch w=2e-06 l=1e-06 \
        as=0 ad=5e-12 ps=0 pd=9e-06 sa=2e-06 sb=2e-06
    Rs1 (5 VSS!) resistor r=50
    Rd4 (VDD!\#2 VDD!\#1) resistor r=2.6962
    Rc18 (VDD!\#2 VDD!\#5) resistor r=2.6224
    Rd2 (Y\#2 Y\#7) resistor r=2.6545
    Rd7 (C\#2 C\#3) resistor r=1936.0317
    Rc10 (Y\#6 Y\#2) resistor r=7.6916
    Rc11 (Y Y\#6) resistor r=4.2472
    Rc8 (D\#2 D\#3) resistor r=2536.0317
    Rd3 (Y Y\#2) resistor r=282.2m
    Rd1 (Y Y\#5) resistor r=5.4
    Rc13 (D\#3 D) resistor r=85.564
    Rd8 (D\#3 D\#4) resistor r=1036.0317
    Rc7 (net2 net2\#2) resistor r=10.1
    Rd9 (C\#3 C) resistor r=85.564
    Rc12 (C\#3 C\#4) resistor r=1636.0317
    Rc5 (net3 net3\#2) resistor r=10.1
    Rc15 (B\#2 B) resistor r=85.564
    Rc9 (B\#2 B\#4) resistor r=1936.0317
    Rd11 (B\#2 B\#3) resistor r=1636.0317
    Rc21 (VDD!\#2 VDD!\#6) resistor r=5.2977
    Rc20 (VDD! VDD!\#2) resistor r=0.134
    Rc17 (VDD! VDD!\#6) resistor r=5.3242
    Rd5 (VDD! VDD!\#4) resistor r=2.6222
    Rc19 (Y\#2 Y\#8) resistor r=3.0334
    Rd6 (Y\#2 Y\#4) resistor r=3.2579
    Rc16 (Y\#8 Y\#4) resistor r=44.0848
    Rd10 (A\#2 A\#3) resistor r=736.0318
    Rc2 (net4 net4\#2) resistor r=10.1
    Rc22 (VSS!\#1 VSS!) resistor r=5.0837
    Rd12 (A\#3 A) resistor r=85.564
    Rc14 (A\#3 A\#4) resistor r=2836.0317
    MX7_M0_unmatched (Y\#6 D\#2 VDD!\#1 VDD!\#1) pch w=4e-06 l=1e-06 as=0 \
        ad=1e-11 ps=0 pd=1.3e-05 sa=2e-06 sb=2e-06
    MX6_M0_unmatched (Y\#7 C\#2 VDD!\#5 VDD!\#5) pch w=4e-06 l=1e-06 as=0 \
        ad=1e-11 ps=0 pd=1.3e-05 sa=2e-06 sb=2e-06
    MX5_M0_unmatched (Y\#8 B\#4 VDD!\#6 VDD!\#6) pch w=4e-06 l=1e-06 as=0 \
        ad=1e-11 ps=0 pd=1.3e-05 sa=2e-06 sb=2e-06
    MX4_M0_unmatched (Y\#4 A\#2 VDD!\#4 VDD!\#4) pch w=4e-06 l=1e-06 as=0 \
        ad=1e-11 ps=0 pd=1.3e-05 sa=2e-06 sb=2e-06
ends NAND4X1_analog_extracted
// End of subcircuit definition.

// Library name: KISTA_SOI_STDLIB2
// Cell name: MX2X1
// View name: analog_extracted
subckt MX2X1_analog_extracted Y A S0 B
    Rs1 (6 VSS!) resistor r=50
    Rc19 (Y Y\#2) resistor r=2.775
    Rc18 (Y Y\#1) resistor r=5.2
    Rc29 (VDD!\#2 VDD!\#1) resistor r=2.7628
    Rc15 (A\#2 A\#3) resistor r=1936.0317
    Rc14 (A\#3 A) resistor r=85.564
    Rc31 (VSS!\#2 VSS!\#1) resistor r=5.2378
    Rc28 (VSS! VSS!\#2) resistor r=0.302
    Rd2 (VDD!\#2 VDD!\#5) resistor r=2.7224
    Rd3 (VDD! VDD!\#2) resistor r=304.7m
    Rd15 (S0\#2 S0\#3) resistor r=4517.6187
    Rd13 (Yn\#6 Yn\#8) resistor r=41.8814
    Rc20 (Yn\#9 Yn\#2310) resistor r=736.0318
    Rd9 (Yn\#2310 Yn\#2311) resistor r=1636.0317
    Rc24 (Yn\#2310 Yn) resistor r=80.464
    Rd10 (Yn Yn\#2) resistor r=5.3795
    Rd7 (A\#3 A\#4) resistor r=436.0318
    Rd14 (Yn\#2 Yn\#6) resistor r=2.8428
    Rc21 (Yn\#2 Yn\#8) resistor r=2.8996
    Rc13 (S0n\#6 S0n\#7) resistor r=1247.7424
    Rd4 (S0n\#6 S0n\#5) resistor r=1557.0614
    Rc12 (S0n\#6 S0n) resistor r=115.9573
    Rc9 (net4 net4\#2) resistor r=5.05
    Rd1 (VDD!\#2 VDD!\#6) resistor r=12.5037
    Rc26 (VDD! VDD!\#6) resistor r=3.5649
    Rc1 (VDD! VDD!\#4) resistor r=2.7222
    Rd8 (S0n S0n\#4) resistor r=10.8692
    Rc16 (S0\#3 S0\#4) resistor r=1336.0317
    Rc2 (net3 net3\#2) resistor r=5.05
    Rd11 (B\#2 B) resistor r=85.564
    Rd6 (B\#2 B\#4) resistor r=736.0318
    Rc27 (VSS!\#2 VSS!\#5) resistor r=5.1974
    Rc10 (net2 net2\#2) resistor r=10.1
    Rd17 (S0\#5 S0\#4) resistor r=1036.0317
    Rd16 (S0\#4 S0) resistor r=85.564
    Rd5 (S0n\#4 S0n\#3) resistor r=10.7015
    Rc11 (S0\#5 S0\#6) resistor r=3317.6187
    Rc17 (S0n S0n\#3) resistor r=20.374
    Rc30 (VSS! VSS!\#4) resistor r=5.1972
    Rc23 (B\#2 B\#3) resistor r=1636.0317
    Rc4 (net1 net1\#2) resistor r=10.1
    Rc5 (VSS! VSS!\#6) resistor r=6.7455
    Rc7 (VSS!\#2 VSS!\#6) resistor r=23.6597
    Rd12 (Yn\#2 Yn\#5) resistor r=5.7021
    Rc22 (Yn\#2 Yn\#3) resistor r=5.5903
    Rc25 (Yn\#3 Yn\#5) resistor r=95.6457
    C1 (VDD!\#1 Y\#2) capacitor c=100.498a
    C10 (Y\#2 Yn\#9) capacitor c=190.794a
    C13 (Y\#2 6) capacitor c=1.00193e-15
    C23 (VDD!\#1 Yn\#9) capacitor c=184.981a
    C91 (Yn\#9 VSS!) capacitor c=3.67826e-18
    C139 (Yn\#9 6) capacitor c=628.237a
    C3 (Y\#2 A\#2) capacitor c=3.7956e-18
    C37 (A\#2 VSS!) capacitor c=8.2381e-18
    C45 (A\#2 6) capacitor c=1.89673e-15
    C6 (VSS! Y) capacitor c=6.30382e-18
    C12 (6 Y) capacitor c=2.16571e-15
    C2 (A Y) capacitor c=5.96324e-18
    C36 (VSS! A) capacitor c=13.847a
    C44 (6 A) capacitor c=5.18091e-15
    C4 (Y\#1 A) capacitor c=3.93853e-18
    C14 (Y\#1 6) capacitor c=1.12335e-15
    C5 (A\#3 Y) capacitor c=6.27598e-19
    C8 (Yn Y) capacitor c=252.757a
    C9 (Y\#2 Yn) capacitor c=93.048a
    C15 (Y\#2 X10_5) capacitor c=450.085a
    C32 (VDD!\#1 X10_5) capacitor c=206.009a
    C149 (Yn\#9 X10_5) capacitor c=508.67a
    C27 (VDD!\#2 6) capacitor c=32.1298f
    C39 (A\#3 VSS!) capacitor c=7.174e-19
    C41 (Yn A) capacitor c=117.27a
    C42 (A\#2 Yn) capacitor c=506.472a
    C43 (A\#3 Yn) capacitor c=3.14403e-18
    C47 (A\#3 6) capacitor c=284.458a
    C90 (Yn VSS!) capacitor c=15.3311a
    C138 (6 Yn) capacitor c=10.7892f
    C7 (VSS!\#1 Y\#1) capacitor c=68.8689a
    C11 (Y\#1 Yn\#2311) capacitor c=240.832a
    C92 (VSS!\#1 Yn\#2311) capacitor c=136.338a
    C98 (VSS!\#2 6) capacitor c=33.2641f
    C140 (Yn\#2311 6) capacitor c=2.13576e-15
    C16 (VDD!\#5 A\#2) capacitor c=183.136a
    C24 (VDD!\#5 Yn) capacitor c=54.9456a
    C18 (VDD!\#2 S0\#2) capacitor c=179.723a
    C53 (S0\#2 VSS!) capacitor c=4.80244e-18
    C70 (S0\#2 6) capacitor c=5.23562e-15
    C19 (VSS! VDD!) capacitor c=46.907a
    C17 (S0\#3 VDD!) capacitor c=1.05671e-15
    C54 (S0\#3 VSS!) capacitor c=4.96741e-19
    C71 (S0\#3 6) capacitor c=5.63104e-15
    C21 (S0n\#7 VDD!) capacitor c=8.42564e-18
    C86 (S0n\#7 VSS!) capacitor c=8.88666e-18
    C125 (S0n\#7 6) capacitor c=1.3237e-15
    C25 (Yn\#8 VDD!) capacitor c=14.3231a
    C94 (Yn\#8 VSS!) capacitor c=6.17236e-18
    C122 (Yn\#8 S0n\#7) capacitor c=147.019a
    C26 (VDD!\#2 Yn\#6) capacitor c=17.9173a
    C67 (Yn\#6 S0\#2) capacitor c=285.078a
    C93 (Yn\#6 VSS!) capacitor c=10.3576a
    C28 (net3 VDD!) capacitor c=14.319a
    C75 (S0\#2 net3) capacitor c=16.5904a
    C130 (S0n\#7 net3) capacitor c=139.36a
    C141 (Yn\#8 net3) capacitor c=78.0821a
    C152 (net3 6) capacitor c=73.9357a
    C30 (VDD!\#5 net4) capacitor c=82.8682a
    C48 (A\#2 net4) capacitor c=139.36a
    C142 (Yn\#9 net4) capacitor c=1.87456e-18
    C154 (net4 6) capacitor c=80.8567a
    C146 (Yn\#2311 net2) capacitor c=1.12473e-18
    C49 (net2 A) capacitor c=61.2663a
    C40 (S0n\#5 A) capacitor c=11.8607a
    C51 (A\#3 net2) capacitor c=3.8832e-18
    C46 (A\#4 6) capacitor c=823.751a
    C50 (A\#4 net2) capacitor c=83.616a
    C87 (S0n\#5 VSS!) capacitor c=22.344a
    C96 (Yn\#2 VSS!) capacitor c=9.95493e-18
    C126 (S0n\#5 6) capacitor c=3.29585e-15
    C144 (Yn\#2 net4) capacitor c=26.0267a
    C148 (Yn\#2 net2) capacitor c=1.08735e-18
    C158 (net2 6) capacitor c=253.121a
    C151 (Yn\#8 X7_5) capacitor c=278.449a
    C135 (S0n\#7 X7_5) capacitor c=521.137a
    C160 (X7_5 net3) capacitor c=301.983a
    C123 (Yn\#2 S0n) capacitor c=1.0004e-15
    C124 (6 S0n) capacitor c=8.0223e-15
    C129 (net3 S0n) capacitor c=1.63536e-18
    C33 (VDD!\#5 X9_5) capacitor c=204.642a
    C52 (A\#2 X9_5) capacitor c=527.868a
    C162 (X9_5 net4) capacitor c=326.694a
    C31 (VDD!\#2 net4\#2) capacitor c=29.6711a
    C77 (net4\#2 S0\#2) capacitor c=139.36a
    C99 (net4\#2 VSS!) capacitor c=1.87456e-18
    C143 (Yn\#6 net4\#2) capacitor c=115.617a
    C155 (net4\#2 6) capacitor c=81.2651a
    C80 (S0\#2 X8_5) capacitor c=504.163a
    C150 (Yn\#6 X8_5) capacitor c=484.351a
    C163 (net4\#2 X8_5) capacitor c=326.694a
    C20 (VDD!\#6 B\#4) capacitor c=180.746a
    C59 (S0\#3 B\#4) capacitor c=19.2916a
    C83 (B\#4 VSS!) capacitor c=3.76184e-18
    C111 (B\#4 6) capacitor c=635.965a
    C22 (VDD!\#4 S0n\#4) capacitor c=151.535a
    C63 (S0n\#4 S0\#3) capacitor c=275.118a
    C88 (S0n\#4 VSS!) capacitor c=56.1907a
    C106 (S0n\#4 B\#4) capacitor c=7.24571e-18
    C127 (S0n\#4 6) capacitor c=3.40323e-15
    C35 (VDD!\#4 X5_5) capacitor c=406.72a
    C81 (S0\#3 X5_5) capacitor c=531.582a
    C137 (S0n\#4 X5_5) capacitor c=186.56a
    C29 (VDD!\#6 net3\#2) capacitor c=100.941a
    C76 (net3\#2 S0\#3) capacitor c=16.5952a
    C58 (S0\#4 VSS!) capacitor c=9.61156e-19
    C66 (S0\#4 S0n\#4) capacitor c=22.9549a
    C74 (S0\#4 6) capacitor c=275.514a
    C116 (net3\#2 B\#4) capacitor c=139.36a
    C131 (net3\#2 S0n) capacitor c=18.2447a
    C153 (net3\#2 6) capacitor c=75.1309a
    C114 (net3 B) capacitor c=22.3064a
    C82 (B VSS!) capacitor c=2.91963e-18
    C104 (S0n B) capacitor c=219.747a
    C105 (S0n\#4 B) capacitor c=8.70111e-18
    C109 (Yn\#2 B) capacitor c=16.4417a
    C110 (6 B) capacitor c=1.0044e-15
    C115 (net3\#2 B) capacitor c=20.2855a
    C85 (B\#2 VSS!) capacitor c=4.60896e-18
    C108 (B\#2 S0n) capacitor c=609.862a
    C113 (B\#2 6) capacitor c=4.23854e-15
    C117 (B\#2 net3\#2) capacitor c=8.02101e-18
    C34 (VDD!\#6 X6_5) capacitor c=210.999a
    C120 (B\#4 X6_5) capacitor c=478.805a
    C161 (net3\#2 X6_5) capacitor c=302.034a
    C136 (S0n\#4 X6_5) capacitor c=22.1574a
    C38 (VSS!\#5 A\#4) capacitor c=135.306a
    C102 (VSS!\#5 net2) capacitor c=46.0379a
    C103 (VSS!\#2 net2\#2) capacitor c=27.911a
    C134 (net2\#2 S0n\#5) capacitor c=83.616a
    C159 (net2\#2 6) capacitor c=253.375a
    C55 (S0\#6 VSS!) capacitor c=140.915a
    C72 (S0\#6 6) capacitor c=4.15585e-15
    C56 (S0\#5 VSS!) capacitor c=944.5a
    C73 (S0\#5 6) capacitor c=4.54422e-15
    C62 (S0n\#4 S0) capacitor c=387.527a
    C64 (S0n\#3 S0) capacitor c=25.3871a
    C65 (S0n\#3 S0\#5) capacitor c=184.115a
    C69 (6 S0) capacitor c=5.01805e-15
    C57 (VSS!\#4 S0) capacitor c=54.804a
    C89 (VSS!\#4 S0n\#3) capacitor c=104.035a
    C128 (S0n\#3 6) capacitor c=667.792a
    C132 (net1 S0n) capacitor c=22.2902a
    C78 (S0\#6 net1) capacitor c=110.374a
    C100 (net1 VSS!) capacitor c=12.8813a
    C133 (S0n\#5 net1) capacitor c=1.12473e-18
    C156 (net1 6) capacitor c=288.65a
    C107 (S0n\#3 B\#3) capacitor c=8.93355e-18
    C60 (B\#3 S0\#6) capacitor c=9.58129e-18
    C61 (S0\#5 B\#3) capacitor c=9.57149e-18
    C79 (net1\#2 S0\#5) capacitor c=1.12473e-18
    C112 (B\#3 6) capacitor c=2.17213e-15
    C157 (net1\#2 6) capacitor c=226.709a
    C118 (net1\#2 B\#3) capacitor c=83.616a
    C119 (B\#2 net1\#2) capacitor c=1.20216e-18
    C68 (Yn\#5 S0\#6) capacitor c=84.7237a
    C145 (Yn\#5 net1) capacitor c=39.041a
    C95 (Yn\#5 VSS!) capacitor c=14.2636a
    C84 (VSS!\#6 B\#3) capacitor c=137.083a
    C101 (VSS!\#6 net1\#2) capacitor c=58.9229a
    C97 (VSS!\#2 Yn\#3) capacitor c=26.5635a
    C121 (Yn\#3 S0n\#5) capacitor c=292.556a
    C147 (Yn\#3 net2\#2) capacitor c=53.5735a
    MX16_M0_unmatched (Y\#1 Yn\#2311 VSS!\#1 VSS!\#1) nch w=2e-06 l=1e-06 \
        as=0 ad=5e-12 ps=0 pd=9e-06 sa=2e-06 sb=2e-06
    MX15_M0_unmatched (net2 A\#4 VSS!\#5 VSS!\#5) nch w=2e-06 l=1e-06 as=0 \
        ad=5e-12 ps=0 pd=9e-06 sa=2e-06 sb=2e-06
    MX11_M0_unmatched (S0n\#3 S0\#5 VSS!\#4 VSS!\#4) nch w=2e-06 l=1e-06 \
        as=0 ad=5e-12 ps=0 pd=9e-06 sa=2e-06 sb=2e-06
    MX13_M0_unmatched (Yn\#5 S0\#6 net1 net1) nch w=2e-06 l=1e-06 as=0 \
        ad=5e-12 ps=0 pd=9e-06 sa=2e-06 sb=2e-06
    MX12_M0_unmatched (net1\#2 B\#3 VSS!\#6 VSS!\#6) nch w=2e-06 l=1e-06 \
        as=0 ad=5e-12 ps=0 pd=9e-06 sa=2e-06 sb=2e-06
    MX14_M0_unmatched (Yn\#3 S0n\#5 net2\#2 net2\#2) nch w=2e-06 l=1e-06 \
        as=0 ad=5e-12 ps=0 pd=9e-06 sa=2e-06 sb=2e-06
    MX10_M0_unmatched (Y\#2 Yn\#9 VDD!\#1 VDD!\#1) pch w=4e-06 l=1e-06 \
        as=0 ad=1e-11 ps=0 pd=1.3e-05 sa=2e-06 sb=2e-06
    MX7_M0_unmatched (Yn\#8 S0n\#7 net3 net3) pch w=4e-06 l=1e-06 as=0 \
        ad=1e-11 ps=0 pd=1.3e-05 sa=2e-06 sb=2e-06
    MX9_M0_unmatched (net4 A\#2 VDD!\#5 VDD!\#5) pch w=4e-06 l=1e-06 as=0 \
        ad=1e-11 ps=0 pd=1.3e-05 sa=2e-06 sb=2e-06
    MX8_M0_unmatched (Yn\#6 S0\#2 net4\#2 net4\#2) pch w=4e-06 l=1e-06 \
        as=0 ad=1e-11 ps=0 pd=1.3e-05 sa=2e-06 sb=2e-06
    MX5_M0_unmatched (S0n\#4 S0\#3 VDD!\#4 VDD!\#4) pch w=4e-06 l=1e-06 \
        as=0 ad=1e-11 ps=0 pd=1.3e-05 sa=2e-06 sb=2e-06
    MX6_M0_unmatched (net3\#2 B\#4 VDD!\#6 VDD!\#6) pch w=4e-06 l=1e-06 \
        as=0 ad=1e-11 ps=0 pd=1.3e-05 sa=2e-06 sb=2e-06
ends MX2X1_analog_extracted
// End of subcircuit definition.

// Library name: KISTA_SOI_STDLIB2
// Cell name: MX4X1
// View name: analog_extracted
subckt MX4X1_analog_extracted D Y B A S0 C S1
    C248 (VDD!\#6 X44_5) capacitor c=46.1985a
    C28 (VDD!\#1 Y\#2) capacitor c=140.489a
    C29 (Y\#2 Yn\#22) capacitor c=325.058a
    C36 (Y\#2 10) capacitor c=1.33547e-15
    C83 (VDD!\#4 VSS!) capacitor c=82.453a
    C95 (S1\#4 VSS!) capacitor c=3.06075e-18
    C108 (Yn\#22 VSS!) capacitor c=2.97089e-18
    C125 (VSS!\#3 10) capacitor c=81.0391f
    C222 (VDD!\#4 S1\#4) capacitor c=1.30209e-15
    C228 (VDD!\#1 Yn\#22) capacitor c=233.92a
    C234 (VDD!\#4 10) capacitor c=78.6397f
    C276 (Yn\#2319 S1) capacitor c=4.59604e-15
    C278 (Yn\#2319 S1\#4) capacitor c=8.09743e-19
    C286 (10 S1) capacitor c=17.6862f
    C293 (S1\#4 10) capacitor c=8.24401e-15
    C351 (Yn\#22 10) capacitor c=1.8281e-15
    C353 (Yn\#2319 10) capacitor c=71.109f
    C1 (D\#4 VSS!) capacitor c=11.831a
    C12 (D\#4 10) capacitor c=4.18077e-15
    C2 (D\#2 VSS!) capacitor c=8.13935e-18
    C13 (D\#2 10) capacitor c=599.327a
    C3 (D\#3 VSS!) capacitor c=10.845a
    C14 (D\#3 10) capacitor c=4.41749e-15
    C4 (VSS!\#3 D) capacitor c=224.92a
    C11 (10 D) capacitor c=2.87351e-15
    C5 (D\#2 S0\#2312) capacitor c=10.1661a
    C200 (S0\#2312 10) capacitor c=2.81712e-15
    C6 (S0\#2311 D\#4) capacitor c=584.344a
    C77 (S0\#2311 VSS!) capacitor c=15.8567a
    C203 (S0\#2311 10) capacitor c=7.62842e-15
    C7 (VDD!\#2 D\#4) capacitor c=13.9788a
    C8 (S0n\#2312 D\#4) capacitor c=605.364a
    C100 (S0n\#2312 VSS!) capacitor c=6.13879e-18
    C176 (S0\#2311 S0n\#2312) capacitor c=385.081a
    C325 (S0n\#2312 10) capacitor c=6.38721e-15
    C9 (Yn\#2317 D\#3) capacitor c=627.566a
    C191 (Yn\#2317 S0\#2311) capacitor c=1.11178e-15
    C78 (S0\#9 VSS!) capacitor c=5.10525e-18
    C177 (S0\#9 S0n\#2312) capacitor c=39.1184a
    C204 (S0\#9 10) capacitor c=8.0748e-15
    C10 (S1n\#5 D\#4) capacitor c=12.6703a
    C120 (S1n\#5 VSS!) capacitor c=9.81953e-18
    C233 (VDD!\#2 S1n\#5) capacitor c=1.24583e-15
    C381 (S1n\#5 10) capacitor c=5.21905e-15
    C15 (D\#4 net13) capacitor c=210.575a
    C130 (net13 VSS!) capacitor c=4.59623e-18
    C339 (S0n\#2312 net13) capacitor c=209.929a
    C403 (net13 10) capacitor c=277.702a
    C16 (net15\#2 D\#4) capacitor c=256.859a
    C131 (net15\#2 VSS!) capacitor c=2.92257e-18
    C246 (VDD!\#2 net15\#2) capacitor c=200.486a
    C407 (net15\#2 10) capacitor c=882.067a
    C434 (net15\#2 net13) capacitor c=84.6238a
    C24 (D\#4 X43_5) capacitor c=532.154a
    C435 (X43_5 net13) capacitor c=163.003a
    C439 (net15\#2 X43_5) capacitor c=152.718a
    C245 (VDD!\#1 net15) capacitor c=218.954a
    C342 (S0n\#2312 net15) capacitor c=28.6724a
    C362 (Yn\#22 net15) capacitor c=3.84387e-18
    C406 (net15 10) capacitor c=927.348a
    C17 (net20 D) capacitor c=73.6976a
    C18 (D\#2 net20) capacitor c=84.1028a
    C20 (D\#3 net20) capacitor c=579.428a
    C23 (D\#3 net19\#2) capacitor c=1.45336e-18
    C21 (net19\#2 D) capacitor c=80.8514a
    C19 (net20\#2 D) capacitor c=66.5382a
    C22 (net19\#2 D\#2) capacitor c=118.603a
    C143 (VSS!\#3 net20) capacitor c=13.9835a
    C214 (S0\#2312 net20) capacitor c=11.6294a
    C371 (Yn\#2317 net20) capacitor c=45.2515a
    C374 (Yn\#2317 net19\#2) capacitor c=4.83751e-18
    C417 (net20 10) capacitor c=737.952a
    C418 (net20\#2 10) capacitor c=1.9318e-15
    C421 (net19\#2 10) capacitor c=665.556a
    C443 (net19\#2 net20) capacitor c=50.7743a
    C142 (net20\#4 VSS!) capacitor c=3.66376e-18
    C304 (net20\#4 S1) capacitor c=56.629a
    C419 (net20\#4 10) capacitor c=711.844a
    C25 (VSS! Y) capacitor c=15.5932a
    C32 (Yn\#2317 Y) capacitor c=438.612a
    C35 (10 Y) capacitor c=2.76622e-15
    C27 (Y\#1 S0\#2312) capacitor c=7.43747e-18
    C33 (Yn\#2317 Y\#1) capacitor c=28.0734a
    C37 (Y\#1 10) capacitor c=1.39536e-15
    C34 (Yn\#23 Y) capacitor c=28.3925a
    C117 (Yn\#23 VSS!) capacitor c=8.82352e-19
    C354 (Yn\#23 10) capacitor c=351.766a
    C375 (Yn\#22 X45_5) capacitor c=464.956a
    C30 (Y\#1 Yn\#24) capacitor c=238.723a
    C38 (Y\#2 X45_5) capacitor c=406.987a
    C247 (VDD!\#1 X45_5) capacitor c=219.85a
    C31 (Yn\#21 Y\#2) capacitor c=38.2566a
    C224 (VDD!\#1 S0n\#2313) capacitor c=52.0298a
    C97 (S0n\#2313 VSS!) capacitor c=10.9141a
    C110 (Yn\#21 VSS!) capacitor c=9.91545e-18
    C309 (Yn\#21 S0n\#2313) capacitor c=172.197a
    C310 (Yn\#21 S0n\#2312) capacitor c=108.602a
    C321 (S0n\#2313 10) capacitor c=1.08611e-15
    C341 (S0n\#2313 net15) capacitor c=219.374a
    C352 (Yn\#24 10) capacitor c=1.90331e-15
    C360 (Yn\#21 net13) capacitor c=4.01613e-18
    C363 (Yn\#21 net15) capacitor c=82.5972a
    C101 (S0n\#2311 VSS!) capacitor c=13.0426a
    C178 (S0n\#2311 S0\#9) capacitor c=2.21052e-15
    C326 (S0n\#2311 10) capacitor c=11.4354f
    C346 (S0n\#2313 X44_5) capacitor c=514.19a
    C376 (Yn\#21 X44_5) capacitor c=180.784a
    C438 (X44_5 net15) capacitor c=152.718a
    C26 (VSS!\#1 Y\#1) capacitor c=107.779a
    C81 (VSS!\#1 S0\#2312) capacitor c=20.5237a
    C109 (VSS!\#1 Yn\#24) capacitor c=188.956a
    C372 (Yn\#24 net19) capacitor c=3.36761e-18
    C144 (VSS!\#1 net19) capacitor c=1.14e-16
    C145 (net19\#2 VSS!\#1) capacitor c=104.292a
    C215 (S0\#2312 net19) capacitor c=160.198a
    C420 (net19 10) capacitor c=606.698a
    C141 (net20\#2 VSS!\#6) capacitor c=68.8998a
    C39 (B\#4 VSS!) capacitor c=13.0548a
    C44 (VDD!\#4 B\#4) capacitor c=11.2689a
    C47 (S1\#4 B\#4) capacitor c=39.8003a
    C55 (B\#4 10) capacitor c=4.20614e-15
    C40 (B\#2 VSS!) capacitor c=20.5042a
    C56 (B\#2 10) capacitor c=634.372a
    C41 (B\#3 VSS!) capacitor c=4.29948e-18
    C45 (B\#3 S1) capacitor c=587.176a
    C48 (S1\#4 B\#3) capacitor c=2.71246e-19
    C51 (Yn\#2319 B\#3) capacitor c=598.015a
    C57 (B\#3 10) capacitor c=4.31995e-15
    C42 (VSS!\#3 B) capacitor c=193.946a
    C54 (10 B) capacitor c=2.62518e-15
    C43 (S0\#8 B\#4) capacitor c=584.348a
    C79 (S0\#8 VSS!) capacitor c=4.18036e-18
    C170 (S0\#8 S1) capacitor c=1.13387e-15
    C174 (S1\#4 S0\#8) capacitor c=3.78237e-19
    C179 (S0\#8 S0n\#2311) capacitor c=35.8418a
    C193 (Yn\#2319 S0\#8) capacitor c=2.25873e-15
    C205 (S0\#8 10) capacitor c=9.32429e-15
    C46 (S1\#2 B\#3) capacitor c=3.43522e-18
    C173 (S1\#2 S0\#8) capacitor c=6.63364e-18
    C277 (Yn\#2319 S1\#2) capacitor c=17.8213a
    C292 (S1\#2 10) capacitor c=84.2546a
    C49 (B\#4 S0n\#9) capacitor c=12.79a
    C98 (S0n\#9 VSS!) capacitor c=15.0929a
    C322 (S0n\#9 10) capacitor c=1.32149e-15
    C50 (S0n\#8 B\#4) capacitor c=607.828a
    C102 (S0n\#8 VSS!) capacitor c=17.2282a
    C180 (S0\#8 S0n\#8) capacitor c=667.311a
    C274 (S1\#4 S0n\#8) capacitor c=601.826a
    C327 (S0n\#8 10) capacitor c=8.45233e-15
    C52 (S1n\#6 B) capacitor c=352.685a
    C53 (B\#3 S1n\#6) capacitor c=1.27059e-18
    C123 (VSS!\#3 S1n\#6) capacitor c=1.56187e-15
    C382 (S1n\#6 10) capacitor c=7.41936e-15
    C58 (B\#4 net11) capacitor c=210.188a
    C333 (S0n\#9 net11) capacitor c=4.47784e-18
    C334 (S0n\#8 net11) capacitor c=208.435a
    C396 (net11 10) capacitor c=248.813a
    C59 (net12\#2 B\#4) capacitor c=312.65a
    C240 (VDD!\#4 net12\#2) capacitor c=179.011a
    C297 (S1\#4 net12\#2) capacitor c=195.318a
    C400 (net12\#2 10) capacitor c=644.004a
    C425 (net12\#2 net11) capacitor c=84.6238a
    C67 (B\#4 X37_5) capacitor c=523.646a
    C251 (VDD!\#4 X37_5) capacitor c=33.7491a
    C426 (X37_5 net11) capacitor c=163.003a
    C430 (net12\#2 X37_5) capacitor c=158.892a
    C128 (net12 VSS!) capacitor c=1.25824e-18
    C239 (VDD!\#4 net12) capacitor c=160.194a
    C336 (S0n\#9 net12) capacitor c=278.481a
    C337 (S0n\#8 net12) capacitor c=22.66a
    C399 (net12 10) capacitor c=667.828a
    C60 (net23 B) capacitor c=77.5462a
    C61 (B\#2 net23) capacitor c=83.9318a
    C63 (B\#3 net23) capacitor c=611.135a
    C66 (B\#3 net22\#2) capacitor c=1.45336e-18
    C64 (net22\#2 B) capacitor c=80.8514a
    C62 (net23\#2 B) capacitor c=56.8212a
    C65 (net22\#2 B\#2) capacitor c=123.991a
    C134 (net23 VSS!) capacitor c=11.4043a
    C138 (VSS!\#3 net22\#2) capacitor c=101.269a
    C298 (net23\#2 S1) capacitor c=286.85a
    C299 (S1\#2 net23\#2) capacitor c=1.67787e-18
    C300 (net22\#2 S1) capacitor c=15.669a
    C389 (net23\#2 S1n\#6) capacitor c=173.73a
    C391 (net22\#2 S1n\#6) capacitor c=117.201a
    C410 (net23 10) capacitor c=701.87a
    C411 (net23\#2 10) capacitor c=2.31517e-15
    C414 (net22\#2 10) capacitor c=642.883a
    C441 (net22\#2 net23) capacitor c=50.7743a
    C137 (VSS!\#3 net22) capacitor c=114.428a
    C413 (net22 10) capacitor c=604.258a
    C68 (A\#3 VSS!) capacitor c=2.25141e-18
    C149 (VDD!\#4 A\#3) capacitor c=17.1702a
    C154 (A\#3 10) capacitor c=3.90089e-15
    C69 (A\#4 VSS!) capacitor c=11.4251a
    C155 (A\#4 10) capacitor c=561.313a
    C70 (A\#2 VSS!) capacitor c=8.67193e-18
    C152 (Yn\#2319 A\#2) capacitor c=625.27a
    C156 (A\#2 10) capacitor c=4.2008e-15
    C71 (VSS!\#3 A) capacitor c=235.472a
    C153 (10 A) capacitor c=2.91212e-15
    C161 (net23\#2 A) capacitor c=66.6915a
    C164 (A\#2 net23\#4) capacitor c=579.035a
    C136 (VSS!\#3 net23\#4) capacitor c=13.4019a
    C162 (net23\#4 A) capacitor c=75.042a
    C159 (net24 A) capacitor c=82.3047a
    C133 (VSS!\#3 net24) capacitor c=177.432a
    C160 (A\#4 net24) capacitor c=118.603a
    C163 (net23\#4 A\#4) capacitor c=84.1366a
    C365 (Yn\#2319 net24) capacitor c=2.79684e-18
    C367 (Yn\#2319 net23\#4) capacitor c=42.8246a
    C408 (net24 10) capacitor c=665.464a
    C412 (net23\#4 10) capacitor c=738.16a
    C440 (net23\#4 net24) capacitor c=50.7743a
    C132 (net24\#2 VSS!) capacitor c=31.1384a
    C409 (net24\#2 10) capacitor c=798.071a
    C72 (S0 VSS!) capacitor c=31.4766a
    C192 (Yn\#2319 S0) capacitor c=290.439a
    C196 (10 S0) capacitor c=7.58434e-15
    C73 (S0\#2310 VSS!) capacitor c=23.2148a
    C197 (S0\#2310 10) capacitor c=1.6774e-15
    C74 (S0\#6 VSS!) capacitor c=22.5054a
    C147 (S0\#6 A\#3) capacitor c=11.3512a
    C198 (S0\#6 10) capacitor c=1.6194e-15
    C75 (S0\#1 VSS!) capacitor c=8.11387e-18
    C199 (S0\#1 10) capacitor c=1.28441e-15
    C76 (S0\#7 VSS!) capacitor c=31.1688a
    C169 (S0\#7 S1) capacitor c=357.702a
    C172 (S1\#2 S0\#7) capacitor c=2.09231e-18
    C201 (S0\#7 10) capacitor c=2.77203e-15
    C212 (S0\#7 net23) capacitor c=11.6294a
    C366 (Yn\#7 net23) capacitor c=11.0633a
    C189 (Yn\#7 S0\#7) capacitor c=164.203a
    C213 (S0\#7 net22) capacitor c=167.806a
    C368 (Yn\#7 net22) capacitor c=50.7743a
    C390 (S1n\#3 net22) capacitor c=24.8907a
    C124 (VSS!\#3 S1n\#3) capacitor c=1.83342e-15
    C279 (S1n\#3 S1) capacitor c=1.08429e-15
    C283 (S1\#2 S1n\#3) capacitor c=6.34357e-18
    C285 (S1\#4 S1n\#3) capacitor c=2.07938e-19
    C383 (S1n\#3 10) capacitor c=14.5948f
    C135 (net23\#2 VSS!\#8) capacitor c=69.04a
    C80 (S0\#5 VSS!) capacitor c=11.7653a
    C148 (S0\#5 A\#3) capacitor c=591.032a
    C181 (S0\#5 S0n\#8) capacitor c=39.1184a
    C194 (Yn\#2319 S0\#5) capacitor c=1.27455e-15
    C206 (S0\#5 10) capacitor c=7.1302e-15
    C171 (S0\#8 S1\#3) capacitor c=293.197a
    C183 (S0n\#7 S0\#5) capacitor c=2.06924e-15
    C88 (S1\#3 VSS!) capacitor c=25.6997a
    C103 (S0n\#7 VSS!) capacitor c=19.8689a
    C151 (S0n\#7 A\#3) capacitor c=604.471a
    C182 (S0n\#7 S0) capacitor c=1.14401e-15
    C221 (VDD!\#4 S1\#3) capacitor c=1.77983e-15
    C272 (S0n\#2311 S1\#3) capacitor c=279.397a
    C273 (S0n\#8 S1\#3) capacitor c=300.735a
    C287 (S1\#3 10) capacitor c=7.33703e-15
    C296 (S1\#3 net12) capacitor c=52.0986a
    C317 (Yn\#2319 S0n\#7) capacitor c=2.28989e-15
    C328 (S0n\#7 10) capacitor c=18.0177f
    C84 (C\#3 VSS!) capacitor c=2.1642e-18
    C167 (S0\#2310 C\#3) capacitor c=11.3512a
    C168 (S0\#9 C\#3) capacitor c=591.032a
    C219 (VDD!\#2 C\#3) capacitor c=14.4998a
    C255 (S0n\#2311 C\#3) capacitor c=604.471a
    C257 (C\#3 S1n\#5) capacitor c=25.1533a
    C259 (C\#3 10) capacitor c=3.90436e-15
    C85 (C\#4 VSS!) capacitor c=14.0569a
    C260 (C\#4 10) capacitor c=599.382a
    C268 (net20\#4 C\#4) capacitor c=83.9654a
    C86 (C\#2 VSS!) capacitor c=3.00591e-18
    C261 (C\#2 10) capacitor c=4.12427e-15
    C269 (C\#2 net20\#4) capacitor c=556.105a
    C87 (VSS!\#3 C) capacitor c=227.666a
    C258 (10 C) capacitor c=2.91212e-15
    C266 (net20\#2 C) capacitor c=66.6915a
    C267 (net20\#4 C) capacitor c=74.948a
    C264 (net21 C) capacitor c=82.3047a
    C139 (VSS!\#3 net21) capacitor c=104.285a
    C265 (C\#4 net21) capacitor c=117.579a
    C415 (net21 10) capacitor c=661.115a
    C442 (net20\#4 net21) capacitor c=50.7743a
    C370 (Yn\#2315 net20\#4) capacitor c=11.6374a
    C118 (VSS!\#3 Yn\#2315) capacitor c=41.374a
    C140 (VSS!\#3 net21\#2) capacitor c=108.933a
    C301 (net21\#2 S1) capacitor c=16.6955a
    C369 (Yn\#2315 net21\#2) capacitor c=50.7743a
    C416 (net21\#2 10) capacitor c=822.047a
    C89 (S1\#5 VSS!) capacitor c=7.36747e-18
    C150 (A\#3 S1\#5) capacitor c=11.0549a
    C288 (S1\#5 10) capacitor c=201.503a
    C90 (S1\#8 VSS!) capacitor c=15.9584a
    C254 (C\#2 S1\#8) capacitor c=583.92a
    C256 (C\#2 Yn\#2312) capacitor c=598.213a
    C186 (Yn\#2312 S0\#9) capacitor c=1.70578e-15
    C195 (S0\#9 S1n) capacitor c=1.04443e-15
    C119 (S1n VSS!) capacitor c=27.2363a
    C232 (VDD!\#2 S1n) capacitor c=1.24767e-15
    C275 (Yn\#2317 S1\#8) capacitor c=273.179a
    C291 (S1\#8 10) capacitor c=5.15608e-15
    C303 (net20\#2 S1\#8) capacitor c=365.27a
    C318 (S0n\#2311 S1n) capacitor c=1.07097e-15
    C349 (S1n\#3 Yn\#2312) capacitor c=1.13144e-15
    C380 (10 S1n) capacitor c=13.7672f
    C280 (S1n\#4 S1) capacitor c=75.0217a
    C284 (S1\#2 S1n\#4) capacitor c=4.38824e-19
    C384 (S1n\#4 10) capacitor c=218.213a
    C91 (VSS!\#6 S1\#9) capacitor c=99.584a
    C302 (net20\#2 S1\#9) capacitor c=487.284a
    C289 (S1\#9 10) capacitor c=1.78412e-15
    C111 (Yn\#20 VSS!) capacitor c=8.89043e-18
    C187 (Yn\#20 S0\#2312) capacitor c=185.484a
    C373 (Yn\#20 net19) capacitor c=50.3566a
    C112 (Yn\#2314 VSS!) capacitor c=7.689e-18
    C188 (Yn\#2314 S0\#2310) capacitor c=205.274a
    C230 (VDD!\#4 Yn\#2314) capacitor c=21.8788a
    C312 (Yn\#2314 S0n\#2311) capacitor c=2.22438e-15
    C350 (Yn\#2314 S1n) capacitor c=87.8062a
    C92 (VSS!\#7 S1) capacitor c=112.043a
    C271 (S0n\#2310 S1) capacitor c=1.05068e-15
    C94 (S1\#2 VSS!\#7) capacitor c=5.94887e-19
    C93 (VSS!\#7 S1\#1) capacitor c=137.134a
    C106 (VSS!\#3 S0n\#2310) capacitor c=31.9979a
    C114 (Yn\#7 VSS!\#7) capacitor c=104.583a
    C113 (Yn\#9 VSS!) capacitor c=21.962a
    C121 (VSS!\#7 S1n\#4) capacitor c=60.4731a
    C281 (S1n\#4 S1\#1) capacitor c=80.8146a
    C290 (S1\#1 10) capacitor c=779.961a
    C311 (Yn\#2315 S0n\#2310) capacitor c=1.08483e-15
    C345 (net21\#2 S0n\#2310) capacitor c=117.579a
    C313 (Yn\#9 S0n\#9) capacitor c=213.408a
    C314 (Yn\#9 S0n\#8) capacitor c=1.24568e-15
    C225 (VDD!\#7 S0n\#8) capacitor c=66.9292a
    C229 (Yn\#9 VDD!\#7) capacitor c=101.411a
    C323 (S0n\#2310 10) capacitor c=5.75338e-15
    C356 (Yn\#9 net11) capacitor c=6.40621e-18
    C358 (Yn\#9 net12) capacitor c=84.6238a
    C347 (S0n\#9 X38_5) capacitor c=515.346a
    C378 (Yn\#9 X38_5) capacitor c=163.003a
    C429 (X38_5 net12) capacitor c=158.892a
    C96 (S0n VSS!) capacitor c=14.598a
    C175 (S0n S0) capacitor c=19.4323a
    C207 (S0\#2 10) capacitor c=7.06578e-18
    C320 (10 S0n) capacitor c=4.01253e-15
    C202 (S0\#4 10) capacitor c=2.87757e-15
    C82 (VSS!\#5 S0\#4) capacitor c=171.039a
    C184 (S0n\#5 S0\#4) capacitor c=91.8565a
    C104 (S0n\#5 VSS!) capacitor c=215.454a
    C329 (S0n\#5 10) capacitor c=7.25191e-15
    C344 (S0n\#5 net24\#2) capacitor c=5.29994e-18
    C316 (S0n\#5 Yn\#5) capacitor c=70.0369a
    C295 (S1\#4 net11\#2) capacitor c=536.679a
    C307 (S1\#4 X36_5) capacitor c=90.3214a
    C387 (net14\#2 S1n) capacitor c=190.681a
    C243 (VDD!\#6 net13\#2) capacitor c=110.706a
    C249 (VDD!\#6 X42_5) capacitor c=354.77a
    C388 (net13\#2 S1n\#5) capacitor c=235.042a
    C392 (S1n\#5 X42_5) capacitor c=452.146a
    C436 (net13\#2 X42_5) capacitor c=318.067a
    C386 (S1n\#5 net14) capacitor c=108.908a
    C241 (VDD!\#2 net14) capacitor c=150.229a
    C242 (VDD!\#2 net14\#2) capacitor c=140.986a
    C244 (VDD!\#2 net13\#4) capacitor c=17.259a
    C431 (net13\#4 net14) capacitor c=84.6238a
    C129 (net14\#2 VSS!) capacitor c=2.19832e-18
    C99 (S0n\#6 VSS!) capacitor c=32.1743a
    C105 (S0n\#4 VSS!) capacitor c=5.52211e-18
    C107 (Yn VSS!) capacitor c=3.43533e-18
    C115 (Yn\#5 VSS!) capacitor c=112.588a
    C315 (Yn\#5 S0n\#6) capacitor c=1.13956e-15
    C116 (Yn\#4 VSS!) capacitor c=4.94229e-18
    C122 (S1n\#2 VSS!) capacitor c=2.80044e-18
    C126 (net10 VSS!) capacitor c=2.40473e-18
    C127 (net11\#4 VSS!) capacitor c=1.44162e-18
    C146 (X39_5 VSS!) capacitor c=9.91316e-18
    C357 (Yn\#4 net11\#4) capacitor c=11.5216a
    C393 (S1n\#2 X39_5) capacitor c=314.732a
    C422 (net11\#4 net10) capacitor c=84.6238a
    C157 (A\#3 net10) capacitor c=171.272a
    C158 (net11\#4 A\#3) capacitor c=636.352a
    C165 (A\#3 X35_5) capacitor c=528.607a
    C423 (X35_5 net10) capacitor c=152.718a
    C428 (net11\#4 X35_5) capacitor c=161.018a
    C185 (S0n\#4 S0\#1) capacitor c=134.691a
    C166 (VDD!\#5 S0\#1) capacitor c=221.172a
    C226 (S0n\#4 VDD!\#5) capacitor c=144.594a
    C218 (S0\#1 X33_5) capacitor c=530.351a
    C253 (VDD!\#5 X33_5) capacitor c=408.586a
    C348 (S0n\#4 X33_5) capacitor c=318.488a
    C227 (Yn VDD!) capacitor c=21.1579a
    C190 (Yn\#4 S0\#6) capacitor c=205.274a
    C209 (net11\#4 S0\#6) capacitor c=11.6294a
    C208 (net10\#2 S0\#6) capacitor c=221.034a
    C235 (net10\#2 VDD!) capacitor c=142.129a
    C355 (net10\#2 Yn\#4) capacitor c=84.6238a
    C217 (S0\#6 X34_5) capacitor c=526.552a
    C379 (Yn\#4 X34_5) capacitor c=163.003a
    C424 (net10\#2 X34_5) capacitor c=152.502a
    C210 (net14\#2 S0\#2310) capacitor c=279.492a
    C211 (net13\#4 S0\#2310) capacitor c=11.6294a
    C216 (S0\#2310 X40_5) capacitor c=518.043a
    C359 (net14\#2 Yn\#2314) capacitor c=84.6238a
    C361 (Yn\#2314 net13\#4) capacitor c=11.5216a
    C377 (Yn\#2314 X40_5) capacitor c=163.003a
    C433 (net14\#2 X40_5) capacitor c=158.676a
    C223 (S0n VDD!) capacitor c=105.594a
    C236 (VDD!\#4 net10) capacitor c=157.515a
    C394 (net10 10) capacitor c=508.207a
    C238 (VDD!\#4 net11\#4) capacitor c=17.0835a
    C308 (Yn S0n) capacitor c=40.8148a
    C324 (S0n\#6 10) capacitor c=5.84596e-15
    C330 (S0n\#4 10) capacitor c=79.2239a
    C331 (net10\#2 S0n) capacitor c=46.1398a
    C385 (S1n\#2 10) capacitor c=78.2895a
    C395 (net10\#2 10) capacitor c=519.285a
    C332 (net10\#2 S0n\#7) capacitor c=19.8327a
    C335 (net11\#4 S0n\#7) capacitor c=207.179a
    C398 (net11\#4 10) capacitor c=193.806a
    C401 (net14 10) capacitor c=483.639a
    C402 (net14\#2 10) capacitor c=521.91a
    C404 (net13\#2 10) capacitor c=725.612a
    C405 (net13\#4 10) capacitor c=184.747a
    C397 (net11\#2 10) capacitor c=500.469a
    C237 (VDD!\#8 net11\#2) capacitor c=109.969a
    C220 (VDD!\#8 S1\#5) capacitor c=144.16a
    C294 (net11\#2 S1\#5) capacitor c=147.756a
    C252 (VDD!\#8 X36_5) capacitor c=309.688a
    C306 (S1\#5 X36_5) capacitor c=356.882a
    C427 (net11\#2 X36_5) capacitor c=316.116a
    C231 (S1n\#2 VDD!\#7) capacitor c=112.285a
    C250 (VDD!\#7 X39_5) capacitor c=159.682a
    C305 (S1\#3 X39_5) capacitor c=493.009a
    C282 (S1n\#2 S1\#3) capacitor c=134.691a
    C262 (C\#3 net14) capacitor c=211.809a
    C263 (net13\#4 C\#3) capacitor c=667.507a
    C270 (C\#3 X41_5) capacitor c=520.137a
    C432 (X41_5 net14) capacitor c=158.892a
    C437 (net13\#4 X41_5) capacitor c=161.018a
    C340 (net13\#4 S0n\#2311) capacitor c=205.474a
    C319 (S1n\#2 S0n\#2311) capacitor c=71.675a
    C338 (net14\#2 S0n\#2311) capacitor c=19.8327a
    C343 (net24\#2 S0n\#6) capacitor c=118.603a
    C364 (Yn\#5 net24\#2) capacitor c=53.572a
    MX56_M0_unmatched (net19\#2 D\#2 net20 net20) nch w=2e-06 l=1e-06 as=0 \
        ad=5e-12 ps=0 pd=9e-06 sa=2e-06 sb=2e-06
    MX58_M0_unmatched (Y\#1 Yn\#24 VSS!\#1 VSS!\#1) nch w=2e-06 l=1e-06 \
        as=0 ad=5e-12 ps=0 pd=9e-06 sa=2e-06 sb=2e-06
    MX50_M0_unmatched (net22\#2 B\#2 net23 net23) nch w=2e-06 l=1e-06 as=0 \
        ad=5e-12 ps=0 pd=9e-06 sa=2e-06 sb=2e-06
    MX48_M0_unmatched (net24 A\#4 net23\#4 net23\#4) nch w=2e-06 l=1e-06 \
        as=0 ad=5e-12 ps=0 pd=9e-06 sa=2e-06 sb=2e-06
    MX51_M0_unmatched (Yn\#7 S0\#7 net22 net22) nch w=2e-06 l=1e-06 as=0 \
        ad=5e-12 ps=0 pd=9e-06 sa=2e-06 sb=2e-06
    MX49_M0_unmatched (net23\#2 S1n\#6 VSS!\#8 VSS!\#8) nch w=2e-06 \
        l=1e-06 as=0 ad=5e-12 ps=0 pd=9e-06 sa=2e-06 sb=2e-06
    MX54_M0_unmatched (net21 C\#4 net20\#4 net20\#4) nch w=2e-06 l=1e-06 \
        as=0 ad=5e-12 ps=0 pd=9e-06 sa=2e-06 sb=2e-06
    MX55_M0_unmatched (net20\#2 S1\#9 VSS!\#6 VSS!\#6) nch w=2e-06 l=1e-06 \
        as=0 ad=5e-12 ps=0 pd=9e-06 sa=2e-06 sb=2e-06
    MX57_M0_unmatched (Yn\#20 S0\#2312 net19 net19) nch w=2e-06 l=1e-06 \
        as=0 ad=5e-12 ps=0 pd=9e-06 sa=2e-06 sb=2e-06
    MX52_M0_unmatched (S1n\#4 S1\#1 VSS!\#7 VSS!\#7) nch w=2e-06 l=1e-06 \
        as=0 ad=5e-12 ps=0 pd=9e-06 sa=2e-06 sb=2e-06
    MX53_M0_unmatched (Yn\#2315 S0n\#2310 net21\#2 net21\#2) nch w=2e-06 \
        l=1e-06 as=0 ad=5e-12 ps=0 pd=9e-06 sa=2e-06 sb=2e-06
    MX46_M0_unmatched (S0n\#5 S0\#4 VSS!\#5 VSS!\#5) nch w=2e-06 l=1e-06 \
        as=0 ad=5e-12 ps=0 pd=9e-06 sa=2e-06 sb=2e-06
    MX47_M0_unmatched (Yn\#5 S0n\#6 net24\#2 net24\#2) nch w=2e-06 l=1e-06 \
        as=0 ad=5e-12 ps=0 pd=9e-06 sa=2e-06 sb=2e-06
    MX45_M0_unmatched (Y\#2 Yn\#22 VDD!\#1 VDD!\#1) pch w=4e-06 l=1e-06 \
        as=0 ad=1e-11 ps=0 pd=1.3e-05 sa=2e-06 sb=2e-06
    MX43_M0_unmatched (net15\#2 D\#4 net13 net13) pch w=4e-06 l=1e-06 as=0 \
        ad=1e-11 ps=0 pd=1.3e-05 sa=2e-06 sb=2e-06
    MX44_M0_unmatched (Yn\#21 S0n\#2313 net15 net15) pch w=4e-06 l=1e-06 \
        as=0 ad=1e-11 ps=0 pd=1.3e-05 sa=2e-06 sb=2e-06
    MX37_M0_unmatched (net12\#2 B\#4 net11 net11) pch w=4e-06 l=1e-06 as=0 \
        ad=1e-11 ps=0 pd=1.3e-05 sa=2e-06 sb=2e-06
    MX38_M0_unmatched (Yn\#9 S0n\#9 net12 net12) pch w=4e-06 l=1e-06 as=0 \
        ad=1e-11 ps=0 pd=1.3e-05 sa=2e-06 sb=2e-06
    MX42_M0_unmatched (net13\#2 S1n\#5 VDD!\#6 VDD!\#6) pch w=4e-06 \
        l=1e-06 as=0 ad=1e-11 ps=0 pd=1.3e-05 sa=2e-06 sb=2e-06
    MX35_M0_unmatched (net10 A\#3 net11\#4 net11\#4) pch w=4e-06 l=1e-06 \
        as=0 ad=1e-11 ps=0 pd=1.3e-05 sa=2e-06 sb=2e-06
    MX33_M0_unmatched (S0n\#4 S0\#1 VDD!\#5 VDD!\#5) pch w=4e-06 l=1e-06 \
        as=0 ad=1e-11 ps=0 pd=1.3e-05 sa=2e-06 sb=2e-06
    MX34_M0_unmatched (Yn\#4 S0\#6 net10\#2 net10\#2) pch w=4e-06 l=1e-06 \
        as=0 ad=1e-11 ps=0 pd=1.3e-05 sa=2e-06 sb=2e-06
    MX40_M0_unmatched (Yn\#2314 S0\#2310 net14\#2 net14\#2) pch w=4e-06 \
        l=1e-06 as=0 ad=1e-11 ps=0 pd=1.3e-05 sa=2e-06 sb=2e-06
    MX36_M0_unmatched (net11\#2 S1\#5 VDD!\#8 VDD!\#8) pch w=4e-06 l=1e-06 \
        as=0 ad=1e-11 ps=0 pd=1.3e-05 sa=2e-06 sb=2e-06
    MX39_M0_unmatched (S1n\#2 S1\#3 VDD!\#7 VDD!\#7) pch w=4e-06 l=1e-06 \
        as=0 ad=1e-11 ps=0 pd=1.3e-05 sa=2e-06 sb=2e-06
    MX41_M0_unmatched (net14 C\#3 net13\#4 net13\#4) pch w=4e-06 l=1e-06 \
        as=0 ad=1e-11 ps=0 pd=1.3e-05 sa=2e-06 sb=2e-06
    Rc60 (VDD!\#2 VDD!\#6) resistor r=2.5488
    Rd3 (S1\#4 S1) resistor r=2623.001
    Rd10 (VSS! VSS!\#3) resistor r=580.9m
    Rs1 (10 VSS!) resistor r=50
    Rd41 (D\#3 D\#2) resistor r=163.6361
    Rc41 (D\#3 D\#4) resistor r=3903.0679
    Rc43 (D\#3 D) resistor r=288.8155
    Rd26 (S0\#2312 S0\#2311) resistor r=2248.2666
    Rc58 (VDD!\#1 VDD!\#2) resistor r=2.8538
    Rc32 (VDD!\#2 VDD!\#4) resistor r=593.4m
    Rc22 (S0\#2311 S0\#9) resistor r=5.9
    Rd13 (Yn\#2317 Yn\#2319) resistor r=1.6885
    Rc46 (net15 net15\#2) resistor r=5.35
    Rd21 (net20 net20\#2) resistor r=15.3
    Rc2 (net20 net20\#4) resistor r=16.218
    Rd20 (net20\#2 net20\#4) resistor r=15.3
    Rc56 (Y Y\#2) resistor r=2.875
    Rc55 (Y Y\#1) resistor r=5.3
    Rd39 (Yn\#23 Yn\#2317) resistor r=85.557
    Rc28 (Yn\#22 Yn\#23) resistor r=1936.0317
    Rd25 (Yn\#23 Yn\#24) resistor r=1636.0317
    Rd14 (Yn\#2317 Yn\#21) resistor r=2.7805
    Rc3 (S0n\#2313 S0n\#2312) resistor r=966.0984
    Rd42 (S0n\#2312 S0n\#2311) resistor r=6
    Rc45 (net19 net19\#2) resistor r=10.2
    Rd31 (VSS!\#1 VSS!\#3) resistor r=5.9834
    Rc61 (VSS!\#1 VSS!\#6) resistor r=91.6803
    Rc57 (VSS!\#6 VSS!\#3) resistor r=5.7497
    Rd29 (B\#3 B\#4) resistor r=3903.0679
    Rc42 (B\#3 B\#2) resistor r=163.6361
    Rd16 (B\#3 B) resistor r=288.8155
    Rc21 (S0\#9 S0\#8) resistor r=0.8
    Rc50 (S1\#2 S1\#4) resistor r=448344.2812
    Rc40 (S1\#2 S1) resistor r=85.9804
    Rd44 (S0n\#2311 S0n\#8) resistor r=0.7
    Rc52 (S0n\#8 S0n\#9) resistor r=1128.2664
    Rc15 (net12 net12\#2) resistor r=5.3
    Rc16 (net22 net22\#2) resistor r=10.2
    Rc38 (net23 net23\#2) resistor r=15.3
    Rd9 (A\#2 A\#4) resistor r=163.6361
    Rc44 (A\#2 A\#3) resistor r=3753.0679
    Rc36 (A\#2 A) resistor r=288.8155
    Rc5 (net24 net24\#2) resistor r=10.2
    Rd36 (net23 net23\#4) resistor r=16.218
    Rc39 (net23\#2 net23\#4) resistor r=15.3
    Rd27 (S0\#9 S0\#2310) resistor r=1571.0985
    Rd18 (S0\#7 S0\#8) resistor r=2253.2666
    Rd35 (S1n\#3 S1n\#6) resistor r=6157.0752
    Rd11 (Yn\#7 Yn\#2319) resistor r=554.1891
    Rd32 (VSS!\#3 VSS!\#8) resistor r=8.8917
    Rc63 (VSS! VSS!\#8) resistor r=12.7258
    Rd19 (S0\#5 S0\#6) resistor r=1571.0985
    Rd7 (S0\#5 S0) resistor r=0.4
    Rc18 (S0\#8 S0\#5) resistor r=0.9
    Rd43 (S0n\#8 S0n\#7) resistor r=1
    Rd1 (S1\#3 S1\#4) resistor r=5486.8765
    Rc54 (S1\#2 S1\#3) resistor r=2236.0317
    Rd4 (C\#2 C\#3) resistor r=3753.0679
    Rc37 (C\#2 C\#4) resistor r=163.6361
    Rd5 (C\#2 C) resistor r=288.8155
    Rc23 (net21 net21\#2) resistor r=10.2
    Rc49 (S1\#4 S1\#5) resistor r=163.6361
    Rd33 (S1n\#5 S1n) resistor r=4807.0757
    Rd34 (S1n S1n\#3) resistor r=1435.853
    Rc20 (S1n\#3 S1n\#4) resistor r=10.1
    Rd2 (S1\#8 S1) resistor r=5.5
    Rd17 (S1\#8 S1\#9) resistor r=1123.2664
    Rc69 (Yn\#2312 Yn\#2315) resistor r=546.053
    Rc71 (Yn\#2312 Yn\#2317) resistor r=21.1057
    Rc66 (Yn\#2317 Yn\#20) resistor r=5.193
    Rc68 (Yn\#2312 Yn\#2319) resistor r=7.0764
    Rd38 (Yn\#2312 Yn\#2314) resistor r=843.478
    Rd8 (S1\#2 S1\#1) resistor r=436.0318
    Rc62 (VSS!\#3 VSS!\#7) resistor r=5.1974
    Rc65 (Yn\#9 Yn\#7) resistor r=93494.7969
    Rc47 (S0n\#2310 S0n\#2311) resistor r=1681.9572
    Rc67 (Yn\#9 Yn\#2319) resistor r=856.2532
    Rc64 (VDD!\#2 VDD!\#7) resistor r=6.1717
    Rc11 (VDD!\#7 VDD!\#4) resistor r=5.1664
    Rc4 (S0\#2 S0) resistor r=85.564
    Rd40 (S0n\#7 S0n) resistor r=394.9496
    Rc17 (S0\#1 S0\#2) resistor r=1336.0317
    Rd6 (S0\#2 S0\#4) resistor r=2236.0317
    Rd12 (VSS! VSS!\#5) resistor r=5.0972
    Rd28 (S0n\#7 S0n\#5) resistor r=1470.5142
    Rc53 (S0n S0n\#5) resistor r=109822.7969
    Rc72 (Yn Yn\#2319) resistor r=856.8542
    Rd15 (Yn\#5 Yn\#2319) resistor r=556.4442
    Rc1 (net13 net13\#2) resistor r=7.6545
    Rd24 (net13 net13\#4) resistor r=8.42
    Rc27 (net11 net11\#4) resistor r=8.42
    Rd22 (net11 net11\#2) resistor r=7.6545
    Rc19 (S1n S1n\#2) resistor r=5.05
    Rc24 (net14 net14\#2) resistor r=5.25
    Rc26 (net13\#2 net13\#4) resistor r=7.7963
    Rd37 (Yn Yn\#5) resistor r=74267.8984
    Rc70 (Yn Yn\#4) resistor r=2.625
    Rd30 (VDD! VDD!\#5) resistor r=2.6222
    Rc6 (net10 net10\#2) resistor r=5.25
    Rc59 (VDD! VDD!\#4) resistor r=307.3m
    Rc7 (VDD!\#4 VDD!\#8) resistor r=2.5488
    Rc48 (S0n S0n\#4) resistor r=2.55
    Rc51 (S0n\#6 S0n\#7) resistor r=1681.9572
    Rd23 (net11\#2 net11\#4) resistor r=7.7963
ends MX4X1_analog_extracted
// End of subcircuit definition.

// Library name: KISTA_SOI_STDLIB2
// Cell name: NOR2X2
// View name: analog_extracted
subckt NOR2X2_analog_extracted Y A B
    Rd1 (Y Y\#3) resistor r=1.575
    Rc5 (B\#2 B\#3) resistor r=736.0318
    Rc2 (net1 net1\#2) resistor r=2.525
    Rc11 (VDD! VDD!\#1) resistor r=1.5238
    Rc1 (B\#3 B) resistor r=85.564
    Rd6 (B\#3 B\#4) resistor r=1936.0317
    Rs1 (3 VSS!) resistor r=50
    Rd2 (A\#2 A\#3) resistor r=1336.0317
    Rd4 (A\#3 A) resistor r=85.564
    Rc7 (A\#3 A\#4) resistor r=1336.0317
    Rc4 (Y Y\#2) resistor r=3.0345
    Rd3 (Y\#4 Y\#2) resistor r=82.6976
    Rc6 (Y Y\#4) resistor r=2.8637
    Rd5 (VSS! VSS!\#3) resistor r=2.6876
    Rc3 (VSS!\#3 VSS!\#2) resistor r=219.0699
    Rc8 (VSS! VSS!\#2) resistor r=2.757
    C13 (Y\#3 B\#2) capacitor c=298.88a
    C17 (Y\#3 3) capacitor c=984.247a
    C20 (Y\#3 net1) capacitor c=156.529a
    C53 (B\#2 3) capacitor c=591.937a
    C57 (B\#2 net1) capacitor c=250.848a
    C61 (net1 3) capacitor c=139.74a
    C4 (Y\#3 VDD!) capacitor c=71.0989a
    C37 (B\#2 VDD!) capacitor c=66.3a
    C38 (3 VDD!) capacitor c=5.16375e-15
    C40 (net1 VDD!) capacitor c=83.533a
    C6 (Y\#3 A\#2) capacitor c=5.09755e-18
    C47 (A\#2 3) capacitor c=1.3273e-15
    C12 (Y\#3 B) capacitor c=98.9692a
    C52 (3 B) capacitor c=5.25399e-15
    C56 (net1 B) capacitor c=26.5314a
    C10 (B Y) capacitor c=279.553a
    C16 (3 Y) capacitor c=3.57953e-15
    C22 (Y\#3 X3_5) capacitor c=636.131a
    C21 (X3_5 Y) capacitor c=2.866e-18
    C60 (B\#2 X3_5) capacitor c=526.868a
    C63 (X3_5 net1) capacitor c=564.605a
    C35 (X3_5 VSS!) capacitor c=6.13238e-18
    C1 (VSS! Y) capacitor c=4.6536e-18
    C28 (B VSS!) capacitor c=4.38534e-18
    C29 (B\#2 VSS!) capacitor c=3.08722e-18
    C15 (B\#3 Y) capacitor c=23.9916a
    C31 (B\#3 VSS!) capacitor c=2.77954e-19
    C32 (3 VSS!) capacitor c=6.70613e-15
    C55 (B\#3 3) capacitor c=293.043a
    C59 (B\#3 net1) capacitor c=1.89413e-18
    C41 (net1\#2 VDD!) capacitor c=11.3766a
    C23 (VDD!\#1 VSS!) capacitor c=18.9744a
    C36 (VDD!\#1 A\#2) capacitor c=347.862a
    C39 (VDD!\#1 3) capacitor c=4.89703e-15
    C42 (VDD!\#1 net1\#2) capacitor c=209.399a
    C50 (net1\#2 A\#2) capacitor c=250.848a
    C58 (net1\#2 B) capacitor c=21.2362a
    C62 (net1\#2 3) capacitor c=140.446a
    C11 (B\#4 Y) capacitor c=847.676a
    C54 (B\#4 3) capacitor c=2.3073e-15
    C43 (VDD!\#1 X2_5) capacitor c=666.792a
    C64 (net1\#2 X2_5) capacitor c=564.513a
    C51 (A\#2 X2_5) capacitor c=503.459a
    C27 (A\#3 VSS!) capacitor c=9.76141e-19
    C45 (A\#3 B) capacitor c=6.21617e-18
    C49 (A\#3 3) capacitor c=313.84a
    C5 (A Y) capacitor c=6.10398e-18
    C24 (A VSS!) capacitor c=15.4008a
    C44 (B A) capacitor c=98.0741a
    C14 (Y\#2 B) capacitor c=10.4139a
    C7 (Y\#2 A) capacitor c=135.522a
    C9 (A\#3 Y\#2) capacitor c=5.32664e-18
    C19 (Y\#2 3) capacitor c=1.56317e-15
    C46 (3 A) capacitor c=5.64623e-15
    C25 (VSS!\#2 A) capacitor c=19.6993a
    C3 (VSS!\#2 Y\#2) capacitor c=183.987a
    C8 (Y\#2 A\#4) capacitor c=258.63a
    C26 (VSS!\#2 A\#4) capacitor c=248.35a
    C34 (VSS!\#2 3) capacitor c=3.84714e-15
    C48 (A\#4 3) capacitor c=1.79654e-15
    C18 (Y\#4 3) capacitor c=687.704a
    C33 (VSS!\#3 3) capacitor c=227.131a
    C2 (VSS!\#3 Y\#4) capacitor c=168.864a
    C30 (VSS!\#3 B\#4) capacitor c=238.438a
    MX4_M0_unmatched (Y\#2 A\#4 VSS!\#2 VSS!\#2) nch w=4e-06 l=1e-06 as=0 \
        ad=1e-11 ps=0 pd=1.3e-05 sa=2e-06 sb=2e-06
    MX5_M0_unmatched (Y\#4 B\#4 VSS!\#3 VSS!\#3) nch w=4e-06 l=1e-06 as=0 \
        ad=1e-11 ps=0 pd=1.3e-05 sa=2e-06 sb=2e-06
    MX3_M0_unmatched (Y\#3 B\#2 net1 net1) pch w=8e-06 l=1e-06 as=0 \
        ad=2e-11 ps=0 pd=2.1e-05 sa=2e-06 sb=2e-06
    MX2_M0_unmatched (net1\#2 A\#2 VDD!\#1 VDD!\#1) pch w=8e-06 l=1e-06 \
        as=0 ad=2e-11 ps=0 pd=2.1e-05 sa=2e-06 sb=2e-06
ends NOR2X2_analog_extracted
// End of subcircuit definition.

// Library name: KISTA_SOI_STDLIB2
// Cell name: NOR2X3
// View name: analog_extracted
subckt NOR2X3_analog_extracted A Y B
    Rs1 (3 VSS!) resistor r=50
    Rd1 (A\#2 A\#3) resistor r=219.2584
    Rc1 (A\#3 A\#4) resistor r=697.4454
    Rd2 (A\#3 A\#5) resistor r=1405.2902
    Rd4 (A\#5 A) resistor r=85.564
    Rc3 (Y\#1 Y) resistor r=2.0167
    Rc10 (B\#4 B) resistor r=85.564
    Rd6 (VSS! VSS!\#3) resistor r=1.8795
    Rd9 (VSS! VSS!\#2) resistor r=1.9142
    Rc12 (VSS!\#3 VSS!\#2) resistor r=105.2131
    Rc2 (A\#5 A\#6) resistor r=1036.0317
    Rc5 (Y Y\#3) resistor r=1.8167
    Rc4 (Y Y\#2) resistor r=2.0946
    Rd3 (B\#4 B\#6) resistor r=1636.0317
    Rd10 (VDD!\#3 VDD!\#2) resistor r=55.1572
    Rc13 (VDD! VDD!\#2) resistor r=2.017
    Rc14 (VDD! VDD!\#3) resistor r=1.9443
    Rc9 (B\#2 B\#3) resistor r=697.4454
    Rd5 (B\#3 B\#5) resistor r=219.2584
    Rc11 (B\#3 B\#4) resistor r=205.2902
    Rd8 (net2 net2\#2) resistor r=5.5383
    Rd7 (net2\#2 net2\#4) resistor r=5.2774
    Rc6 (net2 net2\#4) resistor r=6.7208
    C12 (B\#2 VSS!) capacitor c=3.84681e-18
    C16 (3 VSS!) capacitor c=7.8902e-15
    C19 (net2 VSS!) capacitor c=12.3838a
    C53 (Y\#1 B\#2) capacitor c=355.533a
    C59 (Y\#1 3) capacitor c=673.162a
    C61 (Y\#1 net2) capacitor c=288.644a
    C64 (B\#2 3) capacitor c=903.641a
    C68 (B\#2 net2) capacitor c=294.353a
    C76 (net2 3) capacitor c=1.62173e-15
    C1 (VDD!\#3 VSS!) capacitor c=21.1116a
    C23 (VDD!\#3 3) capacitor c=46.4266a
    C2 (A VSS!) capacitor c=12.6782a
    C36 (3 A) capacitor c=5.37884e-15
    C3 (A\#2 VSS!) capacitor c=6.88622e-19
    C20 (VDD!\#3 A\#2) capacitor c=293.509a
    C37 (A\#2 3) capacitor c=172.626a
    C4 (A\#4 VSS!) capacitor c=5.77487e-18
    C38 (A\#4 3) capacitor c=909.239a
    C6 (A\#3 VSS!) capacitor c=5.60515e-18
    C40 (A\#3 3) capacitor c=1.99258e-15
    C7 (A\#5 VSS!) capacitor c=3.32035e-19
    C41 (A\#5 3) capacitor c=290.806a
    C8 (Y VSS!) capacitor c=12.7248a
    C30 (Y A) capacitor c=7.49683e-18
    C57 (3 Y) capacitor c=2.97972e-15
    C11 (B VSS!) capacitor c=4.28029e-18
    C34 (B A) capacitor c=98.0741a
    C35 (A\#5 B) capacitor c=6.21617e-18
    C50 (B Y) capacitor c=143.824a
    C52 (Y\#1 B) capacitor c=465.535a
    C63 (3 B) capacitor c=5.22944e-15
    C13 (B\#5 VSS!) capacitor c=13.7606a
    C54 (Y\#1 B\#5) capacitor c=181.566a
    C65 (B\#5 3) capacitor c=171.792a
    C15 (B\#4 VSS!) capacitor c=1.7794e-19
    C56 (B\#4 Y\#1) capacitor c=38.6226a
    C67 (B\#4 3) capacitor c=286.542a
    C17 (VSS!\#3 3) capacitor c=219.015a
    C18 (VSS!\#2 3) capacitor c=7.02681e-15
    C5 (VSS!\#2 A\#6) capacitor c=296.829a
    C39 (A\#6 3) capacitor c=1.34995e-15
    C9 (VSS!\#3 Y\#3) capacitor c=228.727a
    C58 (Y\#3 3) capacitor c=605.178a
    C14 (VSS!\#3 B\#6) capacitor c=296.829a
    C51 (B\#6 Y) capacitor c=833.05a
    C10 (VSS!\#2 Y\#2) capacitor c=214.373a
    C32 (Y\#2 A\#6) capacitor c=514.774a
    C31 (Y\#2 A) capacitor c=351.01a
    C45 (net2\#4 A) capacitor c=12.841a
    C33 (A\#5 Y\#2) capacitor c=22.723a
    C49 (A\#5 net2\#4) capacitor c=8.13895e-19
    C46 (net2\#4 A\#2) capacitor c=1.87e-16
    C47 (net2\#4 A\#4) capacitor c=345.493a
    C48 (A\#3 net2\#4) capacitor c=870.974a
    C44 (A\#3 6) capacitor c=75.9639a
    C25 (VDD!\#3 6) capacitor c=186.64a
    C42 (A\#2 6) capacitor c=387.917a
    C43 (A\#4 6) capacitor c=504.281a
    C55 (Y\#2 B) capacitor c=6.63457e-18
    C60 (Y\#2 3) capacitor c=1.88781e-15
    C66 (B\#6 3) capacitor c=1.92393e-15
    C78 (net2\#4 3) capacitor c=663.649a
    C79 (net2\#4 6) capacitor c=150.641a
    C26 (VDD!\#2 6) capacitor c=505.162a
    C21 (VDD!\#2 A\#4) capacitor c=286.359a
    C24 (VDD!\#2 3) capacitor c=3.41065e-15
    C29 (VDD!\#2 net2\#4) capacitor c=284.625a
    C22 (3 VDD!) capacitor c=11.204f
    C77 (net2\#2 3) capacitor c=1.80612e-15
    C27 (net2 VDD!) capacitor c=128.849a
    C28 (VDD!\#3 net2\#2) capacitor c=237.963a
    C69 (net2\#2 B) capacitor c=128.039a
    C72 (9 B) capacitor c=86.8311a
    C62 (Y\#1 9) capacitor c=187.978a
    C70 (net2\#2 B\#5) capacitor c=291.942a
    C71 (B\#4 net2\#2) capacitor c=5.10823e-18
    C73 (B\#2 9) capacitor c=471.08a
    C74 (B\#5 9) capacitor c=411.644a
    C75 (B\#4 9) capacitor c=5.50356e-18
    C80 (9 net2) capacitor c=661.272a
    C81 (net2\#2 9) capacitor c=337.413a
    MX7_M0_unmatched (Y\#1 B\#2 net2 net2) pch w=6e-06 l=1e-06 as=0 \
        ad=1.8e-11 ps=0 pd=1.8e-05 sa=2e-06 sb=2e-06
    MX5_M0_unmatched (net2\#4 A\#2 VDD!\#3 VDD!\#3) pch w=6e-06 l=1e-06 \
        as=0 ad=1.8e-11 ps=0 pd=1.8e-05 sa=2e-06 sb=2e-06
    MX4_M0_unmatched (net2\#4 A\#4 VDD!\#2 VDD!\#2) pch w=6e-06 l=1e-06 \
        as=0 ad=1.8e-11 ps=0 pd=1.8e-05 sa=2e-06 sb=2e-06
    MX6_M0_unmatched (Y\#1 B\#5 net2\#2 net2\#2) pch w=6e-06 l=1e-06 as=0 \
        ad=1.8e-11 ps=0 pd=1.8e-05 sa=2e-06 sb=2e-06
    MX3_M0_unmatched (Y\#3 B\#6 VSS!\#3 VSS!\#3) nch w=6e-06 l=1e-06 as=0 \
        ad=1.5e-11 ps=0 pd=1.7e-05 sa=2e-06 sb=2e-06
    MX2_M0_unmatched (Y\#2 A\#6 VSS!\#2 VSS!\#2) nch w=6e-06 l=1e-06 as=0 \
        ad=1.5e-11 ps=0 pd=1.7e-05 sa=2e-06 sb=2e-06
ends NOR2X3_analog_extracted
// End of subcircuit definition.

// Library name: KISTA_SOI_STDLIB2
// Cell name: NOR3X1
// View name: analog_extracted
subckt NOR3X1_analog_extracted C A Y B
    C2 (C\#2 VSS!) capacitor c=2.01238e-18
    C23 (Y\#4 C\#2) capacitor c=260.27a
    C32 (C\#2 4) capacitor c=1.25565e-15
    C36 (C\#2 net2) capacitor c=139.36a
    C57 (Y\#4 net2) capacitor c=82.8682a
    C80 (net2 4) capacitor c=78.2413a
    C1 (C VSS!) capacitor c=13.7854a
    C31 (4 C) capacitor c=6.34483e-15
    C35 (net2 C) capacitor c=23.0498a
    C4 (C\#3 VSS!) capacitor c=3.04699e-19
    C34 (C\#3 4) capacitor c=355.324a
    C5 (A\#2 VSS!) capacitor c=2.90434e-18
    C47 (A\#2 4) capacitor c=2.74545e-15
    C8 (A\#3 VSS!) capacitor c=1.12191e-18
    C49 (A\#3 4) capacitor c=379.304a
    C9 (Y\#5 VSS!) capacitor c=110.01a
    C13 (VDD! VSS!) capacitor c=11.5155a
    C26 (C\#2 VDD!) capacitor c=66.3a
    C37 (C\#2 X5_5) capacitor c=526.341a
    C21 (X5_5 VSS!) capacitor c=6.13238e-18
    C52 (Y\#4 VDD!) capacitor c=71.0989a
    C59 (Y\#4 X5_5) capacitor c=437.88a
    C85 (X5_5 net2) capacitor c=319.404a
    C22 (Y C) capacitor c=531.709a
    C24 (C\#3 Y) capacitor c=30.4834a
    C61 (4 VDD!) capacitor c=7.398e-15
    C65 (net2 VDD!) capacitor c=76.8452a
    C20 (net2\#2 VSS!) capacitor c=2.20455e-18
    C66 (net2\#2 VDD!) capacitor c=76.8672a
    C81 (net2\#2 4) capacitor c=79.4518a
    C14 (B VSS!) capacitor c=23.0504a
    C27 (B C) capacitor c=20.9718a
    C28 (B\#3 C) capacitor c=1.32925e-18
    C17 (B\#3 VSS!) capacitor c=6.24085e-19
    C29 (C\#3 B) capacitor c=1.32925e-18
    C30 (C\#3 B\#3) capacitor c=8.42507e-20
    C33 (C\#4 4) capacitor c=2.56853e-15
    C43 (A\#3 B) capacitor c=6.01879e-19
    C45 (B\#3 A\#3) capacitor c=3.81485e-20
    C53 (B\#3 Y) capacitor c=3.6392e-19
    C25 (Y\#2 C\#4) capacitor c=797.255a
    C54 (Y\#2 B) capacitor c=13.6874a
    C56 (Y\#2 4) capacitor c=9.69167e-15
    C58 (Y\#2 net2\#2) capacitor c=1.22851e-18
    C69 (4 B) capacitor c=6.82396e-15
    C72 (B\#3 4) capacitor c=375.047a
    C3 (VSS!\#4 C\#4) capacitor c=184.309a
    C11 (Y\#2 VSS!\#4) capacitor c=116.235a
    C18 (VSS!\#2 4) capacitor c=15.4536f
    C12 (VSS!\#2 Y\#3) capacitor c=133.401a
    C40 (A\#3 Y\#3) capacitor c=2.96306e-18
    C15 (B\#2 VSS!) capacitor c=6.41535e-18
    C19 (net1 VSS!) capacitor c=3.43305e-18
    C60 (B\#2 VDD!) capacitor c=49.7084a
    C70 (B\#2 4) capacitor c=1.32939e-15
    C73 (net1 B) capacitor c=7.28235e-18
    C42 (B A) capacitor c=9.49599e-18
    C38 (Y\#3 A) capacitor c=103.152a
    C44 (B\#3 A) capacitor c=6.01879e-19
    C46 (4 A) capacitor c=6.66404e-15
    C74 (B\#2 net1) capacitor c=139.36a
    C75 (B\#3 net1) capacitor c=4.61573e-19
    C76 (net2\#2 B\#2) capacitor c=139.36a
    C78 (net1 4) capacitor c=142.818a
    C82 (net2\#2 net1) capacitor c=79.6223a
    C55 (Y\#2 B\#4) capacitor c=716.353a
    C71 (B\#4 4) capacitor c=2.65606e-15
    C6 (VSS!\#3 A) capacitor c=56.9524a
    C7 (VSS!\#3 A\#4) capacitor c=191.4a
    C39 (Y\#3 A\#4) capacitor c=169.195a
    C48 (A\#4 4) capacitor c=1.44419e-15
    C10 (VSS!\#5 Y\#6) capacitor c=115.513a
    C16 (VSS!\#5 B\#4) capacitor c=189.107a
    C77 (B\#2 X4_5) capacitor c=522.396a
    C86 (net2\#2 X4_5) capacitor c=319.404a
    C67 (X4_5 VDD!) capacitor c=30.6619a
    C83 (X4_5 net1) capacitor c=319.404a
    C41 (VDD!\#1 A\#2) capacitor c=239.843a
    C62 (VDD!\#1 4) capacitor c=7.19273e-15
    C79 (net1\#2 4) capacitor c=79.4518a
    C50 (net1\#2 A\#2) capacitor c=139.36a
    C63 (VDD!\#1 net1) capacitor c=76.8452a
    C64 (VDD!\#1 net1\#2) capacitor c=144.594a
    C51 (A\#2 X3_5) capacitor c=502.932a
    C68 (VDD!\#1 X3_5) capacitor c=474.675a
    C84 (net1\#2 X3_5) capacitor c=319.404a
    MX5_M0_unmatched (Y\#4 C\#2 net2 net2) pch w=4e-06 l=1e-06 as=0 \
        ad=1e-11 ps=0 pd=1.3e-05 sa=2e-06 sb=2e-06
    MX4_M0_unmatched (net2\#2 B\#2 net1 net1) pch w=4e-06 l=1e-06 as=0 \
        ad=1e-11 ps=0 pd=1.3e-05 sa=2e-06 sb=2e-06
    MX3_M0_unmatched (net1\#2 A\#2 VDD!\#1 VDD!\#1) pch w=4e-06 l=1e-06 \
        as=0 ad=1e-11 ps=0 pd=1.3e-05 sa=2e-06 sb=2e-06
    Rs1 (4 VSS!) resistor r=50
    Rd7 (C\#2 C\#3) resistor r=1336.0317
    Rd9 (C\#3 C) resistor r=85.564
    Rc6 (A\#2 A\#3) resistor r=2536.0317
    Rc8 (Y Y\#4) resistor r=2.875
    Rc5 (net2 net2\#2) resistor r=5.05
    Rd2 (Y Y\#5) resistor r=10.9813
    Rc9 (C\#3 C\#4) resistor r=2236.0317
    Rc7 (Y Y\#2) resistor r=382.6m
    Rd3 (B\#3 B) resistor r=85.564
    Rd4 (Y\#5 Y\#2) resistor r=9.8474
    Rc15 (VSS! VSS!\#4) resistor r=7.6791
    Rc16 (VSS!\#4 VSS!\#2) resistor r=15.3582
    Rd5 (VSS! VSS!\#2) resistor r=99.44m
    Rd6 (Y\#2 Y\#3) resistor r=5.276
    Rd1 (B\#2 B\#3) resistor r=1336.0317
    Rc11 (B\#3 B\#4) resistor r=2236.0317
    Rc12 (Y\#2 Y\#6) resistor r=5.0795
    Rc10 (A\#3 A) resistor r=85.564
    Rd8 (A\#3 A\#4) resistor r=1036.0317
    Rc13 (VSS!\#2 VSS!\#3) resistor r=5.1652
    Rc14 (VSS!\#2 VSS!\#5) resistor r=5.0974
    Rc17 (VDD! VDD!\#1) resistor r=2.7905
    Rc3 (net1 net1\#2) resistor r=5.05
    MX8_M0_unmatched (Y\#5 C\#4 VSS!\#4 VSS!\#4) nch w=2e-06 l=1e-06 as=0 \
        ad=5e-12 ps=0 pd=9e-06 sa=2e-06 sb=2e-06
    MX6_M0_unmatched (Y\#3 A\#4 VSS!\#3 VSS!\#3) nch w=2e-06 l=1e-06 as=0 \
        ad=5e-12 ps=0 pd=9e-06 sa=2e-06 sb=2e-06
    MX7_M0_unmatched (Y\#6 B\#4 VSS!\#5 VSS!\#5) nch w=2e-06 l=1e-06 as=0 \
        ad=5e-12 ps=0 pd=9e-06 sa=2e-06 sb=2e-06
ends NOR3X1_analog_extracted
// End of subcircuit definition.

// Library name: KISTA_SOI_STDLIB2
// Cell name: NOR4X1
// View name: analog_extracted
subckt NOR4X1_analog_extracted C D Y A B
    Rs1 (5 VSS!) resistor r=50
    Rc23 (VDD! VDD!\#1) resistor r=2.8572
    Rc2 (net1 net1\#2) resistor r=5.05
    Rd10 (A\#2 A\#3) resistor r=2536.0317
    Rc5 (net2 net2\#2) resistor r=5.05
    Rc7 (net3 net3\#2) resistor r=5.05
    Rd7 (C\#2 C\#3) resistor r=1936.0317
    Rd9 (C\#3 C) resistor r=85.564
    Rc8 (D\#2 D\#3) resistor r=1336.0317
    Rd1 (Y Y\#5) resistor r=2.875
    Rc13 (D\#3 D) resistor r=85.564
    Rc11 (Y Y\#1) resistor r=198.1m
    Rd8 (D\#3 D\#4) resistor r=2236.0317
    Rc12 (C\#3 C\#4) resistor r=1636.0317
    Rc17 (VSS!\#2 VSS!\#6) resistor r=5.0974
    Rc10 (Y\#1 Y\#7) resistor r=9.8566
    Rc16 (Y\#7 Y\#3) resistor r=10.8855
    Rd2 (Y\#1 Y\#3) resistor r=380.7m
    Rc21 (VSS! VSS!\#2) resistor r=99.44m
    Rc9 (B\#2 B\#4) resistor r=1936.0317
    Rc15 (B\#2 B) resistor r=85.564
    Rd11 (B\#2 B\#3) resistor r=1636.0317
    Rd12 (A\#3 A) resistor r=85.564
    Rc14 (A\#3 A\#4) resistor r=1036.0317
    Rc20 (Y\#3 Y\#4) resistor r=5.276
    Rc19 (VSS!\#2 VSS!\#4) resistor r=5.2981
    Rc18 (VSS!\#7 VSS!\#4) resistor r=409.146
    Rd6 (Y\#3 Y\#8) resistor r=5.0795
    Rc22 (VSS!\#2 VSS!\#7) resistor r=5.2285
    Rd4 (VSS!\#5 VSS!\#2) resistor r=15.3582
    Rd3 (Y\#1 Y\#6) resistor r=5.0981
    Rd5 (VSS! VSS!\#5) resistor r=7.6791
    C43 (Y\#5 D\#2) capacitor c=260.27a
    C47 (D\#2 VSS!) capacitor c=1.95867e-18
    C51 (D\#2 5) capacitor c=1.25566e-15
    C55 (D\#2 net3) capacitor c=139.36a
    C70 (Y\#5 net3) capacitor c=82.8682a
    C108 (net3 5) capacitor c=78.2413a
    C2 (D\#2 VDD!) capacitor c=66.3a
    C3 (Y\#5 VDD!) capacitor c=71.0989a
    C5 (VSS! VDD!) capacitor c=10.2965a
    C7 (5 VDD!) capacitor c=9.63892e-15
    C14 (net3 VDD!) capacitor c=76.8452a
    C1 (C\#2 VDD!) capacitor c=66.3a
    C23 (Y\#5 C\#2) capacitor c=4.75482e-18
    C27 (C\#2 VSS!) capacitor c=9.12449e-18
    C35 (C\#2 5) capacitor c=2.03842e-15
    C8 (VDD!\#1 5) capacitor c=9.42396e-15
    C4 (VDD!\#1 A\#2) capacitor c=239.843a
    C73 (A\#2 VSS!) capacitor c=2.39228e-18
    C80 (A\#2 5) capacitor c=2.74569e-15
    C6 (VDD!\#1 B\#4) capacitor c=66.1897a
    C86 (B\#4 VSS!) capacitor c=2.61014e-18
    C95 (B\#4 5) capacitor c=2.04089e-15
    C9 (VDD!\#1 net1) capacitor c=76.8452a
    C90 (net1 VSS!) capacitor c=3.43305e-18
    C99 (B\#4 net1) capacitor c=139.36a
    C104 (net1 5) capacitor c=79.0526a
    C10 (VDD!\#1 net1\#2) capacitor c=144.594a
    C83 (net1\#2 A\#2) capacitor c=139.36a
    C105 (net1\#2 5) capacitor c=79.4518a
    C112 (net1\#2 X4_5) capacitor c=319.404a
    C17 (VDD!\#1 X4_5) capacitor c=474.675a
    C84 (A\#2 X4_5) capacitor c=502.969a
    C13 (VDD!\#1 net2\#2) capacitor c=65.8752a
    C12 (net2\#2 VDD!) capacitor c=10.97a
    C76 (A\#3 VSS!) capacitor c=6.19093e-19
    C82 (A\#3 5) capacitor c=382.174a
    C101 (net2\#2 B\#4) capacitor c=139.36a
    C107 (net2\#2 5) capacitor c=211.296a
    C110 (net2\#2 net1) capacitor c=79.6223a
    C11 (net2 VDD!) capacitor c=76.8452a
    C39 (C\#2 net2) capacitor c=139.36a
    C91 (net2 VSS!) capacitor c=6.15782e-18
    C106 (net2 5) capacitor c=78.5913a
    C15 (net3\#2 VDD!) capacitor c=76.8672a
    C16 (X6_5 VDD!) capacitor c=30.6619a
    C40 (net3\#2 C\#2) capacitor c=139.36a
    C41 (C\#2 X6_5) capacitor c=521.869a
    C92 (net3\#2 VSS!) capacitor c=2.20455e-18
    C109 (net3\#2 5) capacitor c=79.4518a
    C113 (net3\#2 net2) capacitor c=79.6223a
    C114 (X6_5 net2) capacitor c=319.404a
    C117 (net3\#2 X6_5) capacitor c=319.404a
    C38 (net2 C) capacitor c=3.17032e-18
    C71 (Y\#1 net3\#2) capacitor c=1.22851e-18
    C26 (VSS! C) capacitor c=14.2112a
    C29 (C\#3 VSS!) capacitor c=3.02005e-19
    C34 (5 C) capacitor c=6.61918e-15
    C37 (C\#3 5) capacitor c=371.059a
    C69 (Y\#1 5) capacitor c=11.2603f
    C18 (D C) capacitor c=21.7969a
    C19 (C\#3 D) capacitor c=6.38834e-19
    C46 (VSS! D) capacitor c=12.1064a
    C50 (5 D) capacitor c=6.35251e-15
    C54 (net3 D) capacitor c=23.0498a
    C116 (X7_5 net3) capacitor c=319.404a
    C56 (D\#2 X7_5) capacitor c=526.378a
    C20 (D\#3 C) capacitor c=1.38154e-18
    C21 (D\#3 C\#3) capacitor c=4.04908e-20
    C49 (D\#3 VSS!) capacitor c=1.86083e-19
    C53 (D\#3 5) capacitor c=355.816a
    C72 (Y\#5 X7_5) capacitor c=437.88a
    C93 (X7_5 VSS!) capacitor c=6.13238e-18
    C22 (Y C) capacitor c=21.9089a
    C24 (C\#3 Y) capacitor c=1.38864e-18
    C42 (Y D) capacitor c=531.741a
    C44 (D\#3 Y) capacitor c=30.4853a
    C45 (Y\#1 D\#4) capacitor c=797.342a
    C52 (D\#4 5) capacitor c=2.60501e-15
    C25 (Y\#1 C\#4) capacitor c=711.011a
    C36 (C\#4 5) capacitor c=1.99981e-15
    C28 (VSS!\#6 C\#4) capacitor c=190.233a
    C61 (VSS!\#6 Y\#7) capacitor c=164.746a
    C89 (VSS!\#2 5) capacitor c=20.2132f
    C30 (B C) capacitor c=58.3087a
    C31 (B\#2 C) capacitor c=25.8323a
    C32 (C\#3 B) capacitor c=3.69574e-18
    C33 (C\#3 B\#2) capacitor c=1.63731e-18
    C66 (Y\#3 B) capacitor c=17.4204a
    C68 (Y\#3 B\#2) capacitor c=6.70737e-19
    C78 (A\#3 B) capacitor c=6.72e-19
    C85 (B VSS!) capacitor c=8.93241e-19
    C88 (B\#2 VSS!) capacitor c=17.3686a
    C94 (5 B) capacitor c=955.524a
    C97 (B\#2 5) capacitor c=5.81937e-15
    C98 (net1 B) capacitor c=2.71536e-18
    C111 (X5_5 net1) capacitor c=319.404a
    C100 (net2\#2 B) capacitor c=2.57329e-18
    C102 (B\#2 net2\#2) capacitor c=1.63101e-19
    C115 (net2\#2 X5_5) capacitor c=319.369a
    C103 (B\#4 X5_5) capacitor c=521.869a
    C77 (B A) capacitor c=10.6023a
    C67 (Y\#3 B\#3) capacitor c=700.599a
    C79 (5 A) capacitor c=6.70781e-15
    C96 (B\#3 5) capacitor c=1.99972e-15
    C81 (A\#4 5) capacitor c=1.44419e-15
    C59 (A\#3 Y\#4) capacitor c=2.96306e-18
    C57 (Y\#4 A) capacitor c=103.152a
    C74 (VSS!\#4 A) capacitor c=48.9946a
    C58 (Y\#4 A\#4) capacitor c=169.195a
    C62 (VSS!\#4 Y\#4) capacitor c=138.72a
    C75 (VSS!\#4 A\#4) capacitor c=191.394a
    C64 (Y\#3 VSS!\#7) capacitor c=79.6256a
    C65 (VSS!\#2 Y\#8) capacitor c=115.581a
    C87 (VSS!\#7 B\#3) capacitor c=190.906a
    C48 (VSS!\#5 D\#4) capacitor c=184.211a
    C60 (Y\#6 VSS!) capacitor c=103.125a
    C63 (Y\#1 VSS!\#5) capacitor c=49.2334a
    MX10_M0_unmatched (Y\#7 C\#4 VSS!\#6 VSS!\#6) nch w=2e-06 l=1e-06 as=0 \
        ad=5e-12 ps=0 pd=9e-06 sa=2e-06 sb=2e-06
    MX8_M0_unmatched (Y\#4 A\#4 VSS!\#4 VSS!\#4) nch w=2e-06 l=1e-06 as=0 \
        ad=5e-12 ps=0 pd=9e-06 sa=2e-06 sb=2e-06
    MX9_M0_unmatched (Y\#8 B\#3 VSS!\#7 VSS!\#7) nch w=2e-06 l=1e-06 as=0 \
        ad=5e-12 ps=0 pd=9e-06 sa=2e-06 sb=2e-06
    MX11_M0_unmatched (Y\#6 D\#4 VSS!\#5 VSS!\#5) nch w=2e-06 l=1e-06 as=0 \
        ad=5e-12 ps=0 pd=9e-06 sa=2e-06 sb=2e-06
    MX7_M0_unmatched (Y\#5 D\#2 net3 net3) pch w=4e-06 l=1e-06 as=0 \
        ad=1e-11 ps=0 pd=1.3e-05 sa=2e-06 sb=2e-06
    MX4_M0_unmatched (net1\#2 A\#2 VDD!\#1 VDD!\#1) pch w=4e-06 l=1e-06 \
        as=0 ad=1e-11 ps=0 pd=1.3e-05 sa=2e-06 sb=2e-06
    MX5_M0_unmatched (net2\#2 B\#4 net1 net1) pch w=4e-06 l=1e-06 as=0 \
        ad=1e-11 ps=0 pd=1.3e-05 sa=2e-06 sb=2e-06
    MX6_M0_unmatched (net3\#2 C\#2 net2 net2) pch w=4e-06 l=1e-06 as=0 \
        ad=1e-11 ps=0 pd=1.3e-05 sa=2e-06 sb=2e-06
ends NOR4X1_analog_extracted
// End of subcircuit definition.

// Library name: KISTA_SOI_STDLIB2
// Cell name: XOR2X1
// View name: analog_extracted
subckt XOR2X1_analog_extracted A Y B
    Rs1 (4 VSS!) resistor r=50
    Rd11 (A\#2 A\#3) resistor r=3317.6187
    Rd2 (Y Y\#4) resistor r=2.825
    Rd4 (B\#5 B\#6) resistor r=436.0318
    Rc9 (B\#5 B) resistor r=85.564
    Rc10 (B\#4 B\#5) resistor r=2236.0317
    Rd9 (X X\#2) resistor r=5.4795
    Rc2 (X\#2 X\#6) resistor r=2.8231
    Rc24 (VSS! VSS!\#3) resistor r=99.67m
    Rc17 (Y Y\#3) resistor r=5.6169
    Rd1 (B\#3 B\#4) resistor r=3317.6187
    Rc12 (B\#2 B\#3) resistor r=2700
    Rc23 (VSS!\#5 VSS!\#3) resistor r=5.2617
    Rc8 (A\#2 A\#5) resistor r=2700
    Rc3 (net2 net2\#2) resistor r=5.05
    Rd7 (net3 net3\#2) resistor r=8.2548
    Rc19 (VDD! VDD!\#4) resistor r=2.9333
    Rc25 (VSS!\#1 VSS!\#5) resistor r=864.9711
    Rc4 (net1 net1\#2) resistor r=10.1
    Rd5 (Y\#1 Y\#3) resistor r=109.7589
    Rc1 (X\#8 X) resistor r=80.464
    Rd8 (X\#8 X\#9) resistor r=1036.0317
    Rc18 (X\#7 X\#8) resistor r=1636.0317
    Rc20 (Y Y\#1) resistor r=5.5067
    Rc26 (VSS!\#1 VSS!\#3) resistor r=5.4376
    Rc5 (VSS!\#3 VSS!\#6) resistor r=5.1974
    Rc14 (VSS! VSS!\#4) resistor r=5.1972
    Rc22 (net3 net3\#4) resistor r=8.4199
    Rd6 (VDD!\#1 VDD!\#4) resistor r=61.2996
    Rd10 (net3\#2 net3\#4) resistor r=7.2438
    Rc21 (VDD! VDD!\#1) resistor r=3.0508
    Rd13 (A\#3 A\#4) resistor r=2236.0317
    Rd12 (A\#4 A) resistor r=85.564
    Rc11 (A\#4 A\#6) resistor r=436.0318
    Rd3 (VDD! VDD!\#3) resistor r=2.6722
    Rc15 (X\#2 X\#3) resistor r=5.5029
    Rc13 (X\#2 X\#5) resistor r=5.613
    Rc16 (X\#3 X\#5) resistor r=110.5099
    C18 (X\#7 VSS!) capacitor c=2.87489e-18
    C56 (Y\#4 X\#7) capacitor c=284.272a
    C60 (Y\#4 4) capacitor c=1.15392e-15
    C63 (Y\#4 net3) capacitor c=149.512a
    C104 (X\#7 4) capacitor c=1.53458e-15
    C109 (X\#7 net3) capacitor c=268.563a
    C120 (net3 4) capacitor c=1.29721e-15
    C1 (A\#2 VSS!) capacitor c=7.42586e-18
    C42 (A\#2 4) capacitor c=6.13057e-15
    C2 (A\#3 VSS!) capacitor c=13.3931a
    C43 (A\#3 4) capacitor c=5.27468e-15
    C7 (Y VSS!) capacitor c=12.7548a
    C59 (4 Y) capacitor c=2.76364e-15
    C10 (VDD!\#4 VSS!) capacitor c=34.4089a
    C73 (VDD!\#4 4) capacitor c=286.062a
    C11 (B VSS!) capacitor c=23.0999a
    C33 (A\#3 B) capacitor c=9.83119e-18
    C89 (4 B) capacitor c=5.28028e-15
    C12 (B\#2 VSS!) capacitor c=6.12062e-18
    C54 (Y\#4 B\#2) capacitor c=3.28433e-18
    C90 (B\#2 4) capacitor c=2.83196e-15
    C13 (B\#6 VSS!) capacitor c=10.7175a
    C91 (B\#6 4) capacitor c=291.983a
    C14 (B\#5 VSS!) capacitor c=3.49848e-19
    C35 (B\#5 A\#3) capacitor c=6.23124e-19
    C94 (B\#5 4) capacitor c=288.974a
    C17 (X VSS!) capacitor c=5.60551e-18
    C103 (4 X) capacitor c=13.1464f
    C108 (net3 X) capacitor c=38.6897a
    C20 (X\#6 VSS!) capacitor c=3.03177e-18
    C36 (X\#6 A\#2) capacitor c=40.2773a
    C70 (X\#6 VDD!\#4) capacitor c=81.9326a
    C85 (X\#6 B\#6) capacitor c=155.421a
    C23 (X\#2 VSS!) capacitor c=26.8513a
    C87 (X\#2 B) capacitor c=435.6a
    C95 (net2 B) capacitor c=63.0725a
    C26 (net2 VSS!) capacitor c=2.46209e-19
    C47 (A\#2 net2) capacitor c=1.87456e-18
    C88 (X\#2 B\#5) capacitor c=24.3917a
    C96 (B\#6 net2) capacitor c=139.36a
    C97 (B\#5 net2) capacitor c=3.99768e-18
    C93 (B\#4 4) capacitor c=5.74835e-15
    C106 (X\#6 net2) capacitor c=82.8682a
    C118 (net2 4) capacitor c=75.1001a
    C16 (VSS!\#3 B\#4) capacitor c=1.3395e-15
    C25 (VSS!\#3 4) capacitor c=28.3844f
    C9 (VSS!\#3 Y\#3) capacitor c=9.56788e-18
    C62 (Y\#3 4) capacitor c=251.232a
    C15 (VSS!\#3 B\#3) capacitor c=151.839a
    C55 (Y\#3 B\#3) capacitor c=96.5374a
    C84 (B\#3 X) capacitor c=613.496a
    C92 (B\#3 4) capacitor c=6.5703e-15
    C24 (X\#2 VSS!\#5) capacitor c=14.0857a
    C3 (VSS!\#5 A\#5) capacitor c=142.983a
    C34 (B\#4 A\#5) capacitor c=9.58107e-18
    C40 (X\#2 A\#5) capacitor c=607.223a
    C44 (A\#5 4) capacitor c=3.26751e-15
    C27 (net3\#2 VSS!) capacitor c=5.77705e-18
    C98 (net3\#2 B\#2) capacitor c=763.825a
    C110 (X\#6 net3\#2) capacitor c=3.18257e-18
    C117 (X\#6 X4_5) capacitor c=218.57a
    C102 (B\#6 X4_5) capacitor c=549.543a
    C125 (X4_5 net2) capacitor c=280.623a
    C67 (B\#6 VDD!) capacitor c=12.8685a
    C31 (A\#2 VDD!) capacitor c=1.12166e-15
    C32 (A\#3 VDD!) capacitor c=980.826a
    C71 (4 VDD!) capacitor c=14.7956f
    C75 (net2 VDD!) capacitor c=26.8231a
    C48 (net2\#2 A\#3) capacitor c=162.866a
    C76 (net2\#2 VDD!) capacitor c=26.8384a
    C119 (net2\#2 4) capacitor c=78.8182a
    C121 (net3\#2 4) capacitor c=1.11046e-15
    C28 (VSS!\#5 net1\#2) capacitor c=58.9229a
    C50 (net1\#2 A\#5) capacitor c=83.616a
    C100 (net1\#2 B\#4) capacitor c=1.12473e-18
    C114 (X\#2 net1\#2) capacitor c=11.4672a
    C124 (net1\#2 4) capacitor c=227.31a
    C29 (VSS!\#3 net1) capacitor c=12.8813a
    C64 (Y\#3 net1) capacitor c=39.041a
    C99 (B\#3 net1) capacitor c=110.374a
    C8 (Y\#1 VSS!\#1) capacitor c=113.335a
    C57 (Y\#1 X) capacitor c=693.091a
    C61 (Y\#1 4) capacitor c=1.04529e-15
    C112 (net1 X) capacitor c=11.4639a
    C123 (net1 4) capacitor c=227.083a
    C113 (X\#9 net1) capacitor c=1.12473e-18
    C19 (VSS!\#1 X\#9) capacitor c=141.18a
    C58 (Y\#1 X\#9) capacitor c=386.191a
    C105 (X\#9 4) capacitor c=1.35544e-15
    C65 (X7_5 Y) capacitor c=5.70334e-18
    C30 (X7_5 VSS!) capacitor c=6.10172e-18
    C66 (Y\#4 X7_5) capacitor c=405.588a
    C53 (VDD!\#1 Y\#4) capacitor c=29.3052a
    C68 (VDD!\#1 B\#2) capacitor c=194.597a
    C69 (VDD!\#1 X\#7) capacitor c=24.9691a
    C115 (X\#7 X7_5) capacitor c=509.144a
    C127 (X7_5 net3) capacitor c=149.036a
    C49 (net3\#4 A\#2) capacitor c=155.044a
    C72 (VDD!\#1 4) capacitor c=8.96504e-15
    C78 (VDD!\#1 net3\#2) capacitor c=242.935a
    C79 (net3\#4 VDD!\#4) capacitor c=110.552a
    C111 (X\#2 net3\#4) capacitor c=4.41488e-18
    C122 (net3\#4 4) capacitor c=81.4699a
    C80 (VDD!\#1 X6_5) capacitor c=226.143a
    C101 (B\#2 X6_5) capacitor c=533.577a
    C128 (net3\#2 X6_5) capacitor c=454.714a
    C51 (A\#2 X5_5) capacitor c=480.556a
    C81 (VDD!\#4 X5_5) capacitor c=224.7a
    C129 (net3\#4 X5_5) capacitor c=327.517a
    C116 (X\#2 X5_5) capacitor c=22.0633a
    C4 (VSS!\#4 A) capacitor c=75.5148a
    C41 (4 A) capacitor c=5.66745e-15
    C5 (VSS!\#4 A\#6) capacitor c=135.566a
    C45 (A\#6 4) capacitor c=800.545a
    C6 (A\#4 VSS!\#4) capacitor c=4.17988e-18
    C46 (A\#4 4) capacitor c=303.934a
    C74 (VDD!\#3 4) capacitor c=291.931a
    C77 (VDD!\#3 net2\#2) capacitor c=82.8682a
    C37 (X\#3 A) capacitor c=21.2285a
    C21 (VSS!\#6 X\#3) capacitor c=128.707a
    C86 (X\#3 B\#4) capacitor c=787.344a
    C39 (A\#4 X\#3) capacitor c=1.34551e-18
    C82 (X3_5 VDD!) capacitor c=6.13238e-18
    C52 (A\#3 X3_5) capacitor c=504.176a
    C83 (VDD!\#3 X3_5) capacitor c=449.403a
    C126 (net2\#2 X3_5) capacitor c=316.857a
    C107 (X\#5 net2\#2) capacitor c=1.13851e-18
    C22 (X\#5 VSS!\#4) capacitor c=58.4703a
    C38 (X\#5 A\#6) capacitor c=84.7237a
    MX10_M0_unmatched (net1\#2 A\#5 VSS!\#5 VSS!\#5) nch w=2e-06 l=1e-06 \
        as=0 ad=5e-12 ps=0 pd=9e-06 sa=2e-06 sb=2e-06
    MX11_M0_unmatched (Y\#3 B\#3 net1 net1) nch w=2e-06 l=1e-06 as=0 \
        ad=5e-12 ps=0 pd=9e-06 sa=2e-06 sb=2e-06
    MX12_M0_unmatched (Y\#1 X\#9 VSS!\#1 VSS!\#1) nch w=2e-06 l=1e-06 as=0 \
        ad=5e-12 ps=0 pd=9e-06 sa=2e-06 sb=2e-06
    MX9_M0_unmatched (X\#3 B\#4 VSS!\#6 VSS!\#6) nch w=2e-06 l=1e-06 as=0 \
        ad=5e-12 ps=0 pd=9e-06 sa=2e-06 sb=2e-06
    MX8_M0_unmatched (X\#5 A\#6 VSS!\#4 VSS!\#4) nch w=2e-06 l=1e-06 as=0 \
        ad=5e-12 ps=0 pd=9e-06 sa=2e-06 sb=2e-06
    MX7_M0_unmatched (Y\#4 X\#7 net3 net3) pch w=4e-06 l=1e-06 as=0 \
        ad=1e-11 ps=0 pd=1.3e-05 sa=2e-06 sb=2e-06
    MX4_M0_unmatched (X\#6 B\#6 net2 net2) pch w=4e-06 l=1e-06 as=0 \
        ad=1e-11 ps=0 pd=1.3e-05 sa=2e-06 sb=2e-06
    MX6_M0_unmatched (net3\#2 B\#2 VDD!\#1 VDD!\#1) pch w=4e-06 l=1e-06 \
        as=0 ad=1e-11 ps=0 pd=1.3e-05 sa=2e-06 sb=2e-06
    MX5_M0_unmatched (net3\#4 A\#2 VDD!\#4 VDD!\#4) pch w=4e-06 l=1e-06 \
        as=0 ad=1e-11 ps=0 pd=1.3e-05 sa=2e-06 sb=2e-06
    MX3_M0_unmatched (net2\#2 A\#3 VDD!\#3 VDD!\#3) pch w=4e-06 l=1e-06 \
        as=0 ad=1e-11 ps=0 pd=1.3e-05 sa=2e-06 sb=2e-06
ends XOR2X1_analog_extracted
// End of subcircuit definition.

// Library name: KISTA_SOI_STDLIB2
// Cell name: AND2X1
// View name: analog_extracted
subckt AND2X1_analog_extracted A B Y
    C1 (Y\#2 VSS!) capacitor c=6.16489e-18
    C3 (VDD!\#1 Y\#2) capacitor c=140.489a
    C9 (Y\#2 YN\#6) capacitor c=189.321a
    C13 (Y\#2 4) capacitor c=1.29052e-15
    C25 (YN\#6 VSS!) capacitor c=1.92677e-18
    C29 (4 VSS!) capacitor c=6.76582e-15
    C52 (VDD!\#1 YN\#6) capacitor c=238.805a
    C56 (VDD!\#1 4) capacitor c=5.65542e-15
    C76 (YN\#6 4) capacitor c=587.847a
    C5 (Y\#2 B\#2) capacitor c=3.46027e-18
    C22 (B\#2 VSS!) capacitor c=11.0822a
    C68 (B\#2 4) capacitor c=2.43103e-15
    C8 (Y\#2 YN) capacitor c=192.088a
    C51 (VDD!\#1 YN) capacitor c=30.4104a
    C75 (4 YN) capacitor c=13.0236f
    C7 (YN Y) capacitor c=324.88a
    C12 (4 Y) capacitor c=2.8092e-15
    C15 (Y\#2 X5_5) capacitor c=406.72a
    C59 (VDD!\#1 X5_5) capacitor c=212.366a
    C81 (YN\#6 X5_5) capacitor c=508.173a
    C28 (YN\#2 VSS!) capacitor c=20.9238a
    C66 (YN\#2 B\#2) capacitor c=871.763a
    C77 (YN\#8 4) capacitor c=3.4178e-15
    C4 (B Y) capacitor c=7.31565e-18
    C21 (B VSS!) capacitor c=7.03653e-18
    C65 (YN\#2 B) capacitor c=538.549a
    C67 (4 B) capacitor c=6.41272e-15
    C6 (B\#3 Y) capacitor c=4.63684e-19
    C10 (Y\#1 YN\#8) capacitor c=372.885a
    C14 (Y\#1 4) capacitor c=1.408e-15
    C24 (B\#3 VSS!) capacitor c=3.94485e-19
    C70 (B\#3 4) capacitor c=357.212a
    C2 (VSS!\#1 Y\#1) capacitor c=110.858a
    C26 (VSS!\#1 YN\#8) capacitor c=186.6a
    C30 (VSS!\#1 4) capacitor c=8.16593e-15
    C11 (YN\#4 Y\#1) capacitor c=16.7262a
    C78 (YN\#8 net4) capacitor c=1.12473e-18
    C27 (YN\#4 VSS!\#1) capacitor c=91.0597a
    C23 (VSS!\#1 B\#4) capacitor c=76.3515a
    C32 (net4 VSS!) capacitor c=62.6271a
    C63 (YN\#4 B\#4) capacitor c=170.467a
    C64 (B\#3 YN\#4) capacitor c=30.2451a
    C69 (B\#4 4) capacitor c=1.48604e-15
    C71 (net4 B) capacitor c=12.1712a
    C72 (B\#4 net4) capacitor c=83.616a
    C73 (B\#3 net4) capacitor c=7.71439e-19
    C79 (YN\#4 net4) capacitor c=46.0379a
    C84 (net4 4) capacitor c=299.333a
    C33 (net4\#2 VSS!) capacitor c=64.8717a
    C85 (net4\#2 4) capacitor c=238.004a
    C16 (A VSS!) capacitor c=7.23707e-18
    C37 (B A) capacitor c=14.6777a
    C38 (A\#3 B) capacitor c=9.30311e-19
    C19 (A\#3 VSS!) capacitor c=4.05854e-19
    C39 (B\#3 A) capacitor c=4.21496e-19
    C40 (B\#3 A\#3) capacitor c=2.67154e-20
    C44 (4 A) capacitor c=6.6897e-15
    C47 (A\#3 4) capacitor c=380.063a
    C17 (A\#2 VSS!) capacitor c=9.56069e-18
    C45 (A\#2 4) capacitor c=1.26397e-15
    C20 (VDD!\#4 VSS!) capacitor c=21.5332a
    C31 (VSS!\#2 4) capacitor c=542.224a
    C34 (VSS!\#2 net4\#2) capacitor c=39.1322a
    C50 (VDD!\#4 B\#2) capacitor c=234.793a
    C57 (VDD!\#4 4) capacitor c=36.9004a
    C55 (4 VDD!) capacitor c=9.02244e-15
    C18 (VSS!\#2 A\#4) capacitor c=194.763a
    C46 (A\#4 4) capacitor c=2.79459e-15
    C58 (VDD!\#3 4) capacitor c=45.4304a
    C35 (VDD!\#3 A) capacitor c=19.3507a
    C41 (YN\#3 A) capacitor c=142.802a
    C36 (VDD!\#3 A\#2) capacitor c=238.688a
    C42 (YN\#3 A\#2) capacitor c=258.561a
    C43 (A\#3 YN\#3) capacitor c=5.47631e-18
    C48 (net4\#2 A\#4) capacitor c=83.616a
    C80 (net4\#2 YN\#3) capacitor c=1.56407e-18
    C54 (VDD!\#3 YN\#3) capacitor c=178.905a
    C53 (VDD!\#4 YN\#5) capacitor c=202.33a
    C61 (X3_5 VDD!) capacitor c=30.6619a
    C49 (A\#2 X3_5) capacitor c=531.582a
    C62 (VDD!\#3 X3_5) capacitor c=406.72a
    C83 (YN\#3 X3_5) capacitor c=181.705a
    C60 (VDD!\#4 X4_5) capacitor c=148.996a
    C74 (B\#2 X4_5) capacitor c=531.824a
    C82 (YN\#5 X4_5) capacitor c=148.996a
    MX5_M0_unmatched (Y\#2 YN\#6 VDD!\#1 VDD!\#1) pch w=4e-06 l=1e-06 as=0 \
        ad=1e-11 ps=0 pd=1.3e-05 sa=2e-06 sb=2e-06
    MX3_M0_unmatched (YN\#3 A\#2 VDD!\#3 VDD!\#3) pch w=4e-06 l=1e-06 as=0 \
        ad=1e-11 ps=0 pd=1.3e-05 sa=2e-06 sb=2e-06
    MX4_M0_unmatched (YN\#5 B\#2 VDD!\#4 VDD!\#4) pch w=4e-06 l=1e-06 as=0 \
        ad=1e-11 ps=0 pd=1.3e-05 sa=2e-06 sb=2e-06
    Rs1 (4 VSS!) resistor r=50
    Rc9 (Y Y\#2) resistor r=2.875
    Rd2 (YN\#6 YN\#7) resistor r=736.0318
    Rd4 (YN\#7 YN) resistor r=80.464
    Rc12 (YN\#7 YN\#8) resistor r=2836.0317
    Rc11 (YN YN\#2) resistor r=5.093
    Rc8 (Y Y\#1) resistor r=5.3
    Rc5 (B\#2 B\#3) resistor r=2536.0317
    Rc1 (B\#3 B) resistor r=85.564
    Rc14 (VSS!\#1 VSS!) resistor r=5.2382
    Rd3 (B\#3 B\#4) resistor r=1036.0317
    Rc10 (YN\#2 YN\#4) resistor r=5.493
    Rc3 (net4 net4\#2) resistor r=10.1
    Rd9 (A\#3 A) resistor r=85.564
    Rd7 (A\#2 A\#3) resistor r=1336.0317
    Rc15 (VSS! VSS!\#2) resistor r=5.0972
    Rc6 (VDD!\#1 VDD!\#4) resistor r=111.9025
    Rd8 (VDD! VDD!\#1) resistor r=2.8307
    Rd1 (VDD! VDD!\#4) resistor r=2.7532
    Rc4 (A\#3 A\#4) resistor r=2236.0317
    Rd5 (YN\#2 YN\#3) resistor r=2.846
    Rd6 (YN\#2 YN\#5) resistor r=2.668
    Rc7 (VDD! VDD!\#3) resistor r=2.6222
    MX8_M0_unmatched (Y\#1 YN\#8 VSS!\#1 VSS!\#1) nch w=2e-06 l=1e-06 as=0 \
        ad=5e-12 ps=0 pd=9e-06 sa=2e-06 sb=2e-06
    MX7_M0_unmatched (YN\#4 B\#4 net4 net4) nch w=2e-06 l=1e-06 as=0 \
        ad=5e-12 ps=0 pd=9e-06 sa=2e-06 sb=2e-06
    MX6_M0_unmatched (net4\#2 A\#4 VSS!\#2 VSS!\#2) nch w=2e-06 l=1e-06 \
        as=0 ad=5e-12 ps=0 pd=9e-06 sa=2e-06 sb=2e-06
ends AND2X1_analog_extracted
// End of subcircuit definition.

// Library name: KISTA_SOI_STDLIB2
// Cell name: AND3X1
// View name: analog_extracted
subckt AND3X1_analog_extracted A B C Y
    C2 (VDD!\#1 Y\#2) capacitor c=140.489a
    C8 (VDD!\#1 YN\#8) capacitor c=238.805a
    C40 (Y\#2 VSS!) capacitor c=6.16489e-18
    C44 (Y\#2 YN\#8) capacitor c=189.321a
    C48 (Y\#2 5) capacitor c=1.29052e-15
    C72 (YN\#8 VSS!) capacitor c=1.92677e-18
    C76 (5 VSS!) capacitor c=8.99336e-15
    C98 (YN\#8 5) capacitor c=587.847a
    C5 (VDD!\#5 VSS!) capacitor c=32.401a
    C1 (VDD!\#5 C\#2) capacitor c=234.793a
    C18 (Y\#2 C\#2) capacitor c=3.46027e-18
    C21 (C\#2 VSS!) capacitor c=13.3734a
    C33 (C\#2 5) capacitor c=2.42858e-15
    C7 (VDD!\#1 YN) capacitor c=30.4104a
    C43 (Y\#2 YN) capacitor c=191.195a
    C97 (5 YN) capacitor c=15.033f
    C9 (VDD!\#5 YN\#6) capacitor c=176.284a
    C12 (VDD!\#2 5) capacitor c=19.3577f
    C13 (VDD!\#1 X7_5) capacitor c=212.366a
    C50 (Y\#2 X7_5) capacitor c=406.72a
    C103 (YN\#8 X7_5) capacitor c=508.173a
    C42 (YN Y) capacitor c=324.88a
    C47 (5 Y) capacitor c=2.8092e-15
    C31 (YN\#2 C\#2) capacitor c=868.448a
    C75 (YN\#2 VSS!) capacitor c=40.4575a
    C99 (YN\#2310 5) capacitor c=3.41776e-15
    C104 (YN\#6 X6_5) capacitor c=148.996a
    C14 (VDD!\#5 X6_5) capacitor c=148.996a
    C39 (C\#2 X6_5) capacitor c=531.824a
    C19 (C\#3 Y) capacitor c=4.63684e-19
    C23 (C\#3 VSS!) capacitor c=4.71862e-19
    C35 (C\#3 5) capacitor c=356.561a
    C17 (Y C) capacitor c=7.31565e-18
    C20 (VSS! C) capacitor c=17.2322a
    C32 (5 C) capacitor c=6.33588e-15
    C45 (Y\#1 YN\#2310) capacitor c=372.885a
    C49 (Y\#1 5) capacitor c=1.408e-15
    C24 (B C) capacitor c=20.9712a
    C26 (C\#3 B) capacitor c=1.3292e-18
    C68 (B VSS!) capacitor c=14.8878a
    C85 (YN\#2 B) capacitor c=15.8185a
    C88 (5 B) capacitor c=6.82949e-15
    C25 (B\#3 C) capacitor c=1.3292e-18
    C27 (C\#3 B\#3) capacitor c=8.42481e-20
    C71 (B\#3 VSS!) capacitor c=6.63178e-19
    C87 (YN\#2 B\#3) capacitor c=3.30853e-19
    C91 (B\#3 5) capacitor c=373.386a
    C28 (YN\#5 C) capacitor c=531.57a
    C36 (net3 C) capacitor c=46.786a
    C30 (C\#3 YN\#5) capacitor c=30.4744a
    C38 (C\#3 net3) capacitor c=1.09427e-19
    C29 (YN\#5 C\#4) capacitor c=167.909a
    C34 (C\#4 5) capacitor c=1.46409e-15
    C37 (C\#4 net3) capacitor c=83.616a
    C46 (YN\#5 Y\#1) capacitor c=16.7262a
    C100 (YN\#2310 net3) capacitor c=1.12473e-18
    C101 (YN\#5 net3) capacitor c=46.0379a
    C109 (net3 5) capacitor c=236.848a
    C22 (VSS!\#1 C\#4) capacitor c=75.9502a
    C74 (YN\#5 VSS!\#1) capacitor c=91.0597a
    C41 (VSS!\#1 Y\#1) capacitor c=110.858a
    C73 (VSS!\#1 YN\#2310) capacitor c=187.568a
    C77 (VSS!\#1 5) capacitor c=10.4233f
    C82 (VSS!\#1 net3) capacitor c=72.6356a
    C83 (net3\#2 VSS!) capacitor c=53.3931a
    C84 (net3\#2 VSS!\#1) capacitor c=20.7382a
    C102 (YN\#2 net3\#2) capacitor c=1.56407e-18
    C110 (net3\#2 5) capacitor c=237.976a
    C51 (VSS! A) capacitor c=9.61101e-18
    C55 (B A) capacitor c=14.9774a
    C57 (B\#3 A) capacitor c=4.30717e-19
    C62 (5 A) capacitor c=6.66152e-15
    C3 (VDD!\#4 A) capacitor c=19.3507a
    C4 (VDD!\#4 A\#2) capacitor c=238.688a
    C52 (A\#2 VSS!) capacitor c=9.55466e-18
    C63 (A\#2 5) capacitor c=1.26397e-15
    C11 (VDD!\#4 YN\#4) capacitor c=178.905a
    C59 (YN\#4 A) capacitor c=134.368a
    C54 (A\#3 VSS!) capacitor c=5.58326e-19
    C56 (A\#3 B) capacitor c=9.49303e-19
    C92 (net4 B) capacitor c=12.1712a
    C58 (B\#3 A\#3) capacitor c=2.72999e-20
    C60 (YN\#4 A\#2) capacitor c=258.561a
    C61 (A\#3 YN\#4) capacitor c=4.94174e-18
    C65 (A\#3 5) capacitor c=378.266a
    C79 (net4 VSS!) capacitor c=74.1313a
    C94 (B\#3 net4) capacitor c=7.71439e-19
    C107 (net4 5) capacitor c=299.333a
    C111 (net3\#2 net4) capacitor c=39.8112a
    C64 (A\#4 5) capacitor c=2.78908e-15
    C67 (A\#2 X4_5) capacitor c=531.582a
    C16 (VDD!\#4 X4_5) capacitor c=437.382a
    C106 (YN\#4 X4_5) capacitor c=181.705a
    C86 (YN\#2 B\#2) capacitor c=821.295a
    C69 (B\#2 VSS!) capacitor c=14.6898a
    C89 (B\#2 5) capacitor c=2.45053e-15
    C70 (B\#4 VSS!) capacitor c=74.9293a
    C90 (B\#4 5) capacitor c=1.45623e-15
    C93 (B\#4 net4) capacitor c=83.616a
    C95 (net3\#2 B\#4) capacitor c=83.616a
    C66 (net4\#2 A\#4) capacitor c=83.616a
    C80 (net4\#2 VSS!) capacitor c=66.4358a
    C53 (VSS!\#2 A\#4) capacitor c=191.712a
    C78 (VSS!\#2 5) capacitor c=527.888a
    C81 (VSS!\#2 net4\#2) capacitor c=39.1322a
    C108 (net4\#2 5) capacitor c=238.004a
    C6 (VDD!\#6 B\#2) capacitor c=234.793a
    C10 (VDD!\#6 YN\#7) capacitor c=230.145a
    C15 (VDD!\#6 X5_5) capacitor c=148.996a
    C96 (B\#2 X5_5) capacitor c=531.824a
    C105 (YN\#7 X5_5) capacitor c=148.996a
    MX7_M0_unmatched (Y\#2 YN\#8 VDD!\#1 VDD!\#1) pch w=4e-06 l=1e-06 as=0 \
        ad=1e-11 ps=0 pd=1.3e-05 sa=2e-06 sb=2e-06
    MX6_M0_unmatched (YN\#6 C\#2 VDD!\#5 VDD!\#5) pch w=4e-06 l=1e-06 as=0 \
        ad=1e-11 ps=0 pd=1.3e-05 sa=2e-06 sb=2e-06
    MX4_M0_unmatched (YN\#4 A\#2 VDD!\#4 VDD!\#4) pch w=4e-06 l=1e-06 as=0 \
        ad=1e-11 ps=0 pd=1.3e-05 sa=2e-06 sb=2e-06
    MX5_M0_unmatched (YN\#7 B\#2 VDD!\#6 VDD!\#6) pch w=4e-06 l=1e-06 as=0 \
        ad=1e-11 ps=0 pd=1.3e-05 sa=2e-06 sb=2e-06
    Rs1 (5 VSS!) resistor r=50
    Rd6 (VDD!\#2 VDD!\#1) resistor r=2.6962
    Rc13 (Y Y\#2) resistor r=2.875
    Rc8 (YN\#8 YN\#9) resistor r=736.0318
    Rc7 (YN\#9 YN) resistor r=80.464
    Rd8 (YN\#9 YN\#2310) resistor r=2836.0317
    Rd1 (YN YN\#2) resistor r=5.093
    Rc17 (YN\#2 YN\#6) resistor r=2.668
    Rc19 (VDD!\#2 VDD!\#5) resistor r=2.6224
    Rd10 (C\#2 C\#3) resistor r=2536.0317
    Rc12 (Y Y\#1) resistor r=5.3
    Rd12 (C\#3 C) resistor r=85.564
    Rd9 (B\#3 B) resistor r=85.564
    Rc6 (C\#3 C\#4) resistor r=1036.0317
    Rd3 (YN\#2 YN\#5) resistor r=5.493
    Rc5 (net3 net3\#2) resistor r=10.1
    Rc20 (VSS!\#1 VSS!) resistor r=5.3048
    Rc9 (A\#3 A) resistor r=85.564
    Rd2 (YN\#2 YN\#4) resistor r=3.2474
    Rc10 (A\#2 A\#3) resistor r=1336.0317
    Rd11 (A\#3 A\#4) resistor r=2236.0317
    Rd4 (VDD! VDD!\#4) resistor r=2.6222
    Rc18 (YN\#7 YN\#4) resistor r=45.1083
    Rc14 (YN\#2 YN\#7) resistor r=3.0236
    Rd7 (B\#2 B\#3) resistor r=2536.0317
    Rc11 (B\#3 B\#4) resistor r=1036.0317
    Rc3 (net4 net4\#2) resistor r=10.1
    Rc21 (VSS! VSS!\#2) resistor r=5.0972
    Rc16 (VDD! VDD!\#2) resistor r=0.134
    Rd5 (VDD!\#2 VDD!\#6) resistor r=5.2977
    Rc15 (VDD! VDD!\#6) resistor r=5.3242
    MX10_M0_unmatched (YN\#5 C\#4 net3 net3) nch w=2e-06 l=1e-06 as=0 \
        ad=5e-12 ps=0 pd=9e-06 sa=2e-06 sb=2e-06
    MX11_M0_unmatched (Y\#1 YN\#2310 VSS!\#1 VSS!\#1) nch w=2e-06 l=1e-06 \
        as=0 ad=5e-12 ps=0 pd=9e-06 sa=2e-06 sb=2e-06
    MX9_M0_unmatched (net3\#2 B\#4 net4 net4) nch w=2e-06 l=1e-06 as=0 \
        ad=5e-12 ps=0 pd=9e-06 sa=2e-06 sb=2e-06
    MX8_M0_unmatched (net4\#2 A\#4 VSS!\#2 VSS!\#2) nch w=2e-06 l=1e-06 \
        as=0 ad=5e-12 ps=0 pd=9e-06 sa=2e-06 sb=2e-06
ends AND3X1_analog_extracted
// End of subcircuit definition.

// Library name: KISTA_SOI_STDLIB2
// Cell name: AND4X1
// View name: analog_extracted
subckt AND4X1_analog_extracted A B C D Y
    C20 (YN\#2310 VSS!) capacitor c=1.92677e-18
    C24 (6 VSS!) capacitor c=11.2518f
    C73 (VDD!\#1 Y\#2) capacitor c=140.489a
    C76 (VDD!\#1 YN\#2310) capacitor c=238.805a
    C100 (Y\#2 YN\#2310) capacitor c=189.321a
    C104 (Y\#2 6) capacitor c=850.403a
    C120 (YN\#2310 6) capacitor c=587.847a
    C1 (C VSS!) capacitor c=11.2079a
    C47 (6 C) capacitor c=6.63089e-15
    C2 (C\#2 VSS!) capacitor c=15.5516a
    C48 (C\#2 6) capacitor c=1.81534e-15
    C4 (C\#3 VSS!) capacitor c=1.12499e-19
    C50 (C\#3 6) capacitor c=372.374a
    C5 (D VSS!) capacitor c=15.349a
    C35 (D C) capacitor c=20.5442a
    C36 (C\#3 D) capacitor c=5.59434e-19
    C62 (6 D) capacitor c=6.34273e-15
    C6 (D\#2 VSS!) capacitor c=16.7639a
    C63 (D\#2 6) capacitor c=2.46603e-15
    C8 (D\#3 VSS!) capacitor c=3.40092e-19
    C37 (D\#3 C) capacitor c=1.30214e-18
    C38 (D\#3 C\#3) capacitor c=3.54583e-20
    C65 (D\#3 6) capacitor c=356.995a
    C9 (VDD!\#7 VSS!) capacitor c=41.2947a
    C39 (VDD!\#7 C\#2) capacitor c=234.793a
    C10 (A VSS!) capacitor c=8.01277e-18
    C92 (6 A) capacitor c=6.51743e-15
    C11 (A\#2 VSS!) capacitor c=8.51527e-18
    C93 (A\#2 6) capacitor c=599.791a
    C13 (A\#3 VSS!) capacitor c=2.34796e-19
    C95 (A\#3 6) capacitor c=359.36a
    C14 (Y VSS!) capacitor c=9.02059e-18
    C56 (Y D) capacitor c=8.88179e-18
    C57 (D\#3 Y) capacitor c=5.62949e-19
    C103 (6 Y) capacitor c=2.78131e-15
    C16 (B VSS!) capacitor c=1.45151e-18
    C40 (B C) capacitor c=58.3087a
    C42 (C\#3 B) capacitor c=3.69574e-18
    C87 (B A) capacitor c=10.6023a
    C88 (A\#3 B) capacitor c=6.72e-19
    C110 (6 B) capacitor c=978.273a
    C17 (B\#4 VSS!) capacitor c=12.2271a
    C111 (B\#4 6) capacitor c=1.81549e-15
    C18 (B\#3 VSS!) capacitor c=67.1792a
    C112 (B\#3 6) capacitor c=2.0796e-15
    C19 (B\#2 VSS!) capacitor c=17.0509a
    C41 (B\#2 C) capacitor c=25.8323a
    C43 (C\#3 B\#2) capacitor c=1.63731e-18
    C113 (B\#2 6) capacitor c=5.8164e-15
    C23 (YN\#4 VSS!) capacitor c=48.8487a
    C107 (YN\#4 B) capacitor c=19.8732a
    C108 (YN\#4 B\#4) capacitor c=841.707a
    C109 (YN\#4 B\#2) capacitor c=7.25281e-19
    C118 (B\#2 net3\#2) capacitor c=1.21532e-18
    C31 (net3\#2 VSS!) capacitor c=74.1524a
    C116 (net3\#2 B) capacitor c=2.7505e-18
    C114 (net4 B) capacitor c=2.9388e-18
    C27 (net4 VSS!) capacitor c=74.1313a
    C115 (B\#3 net4) capacitor c=83.616a
    C117 (net3\#2 B\#3) capacitor c=83.616a
    C131 (net4 6) capacitor c=237.766a
    C134 (net3\#2 6) capacitor c=366.89a
    C137 (net3\#2 net4) capacitor c=39.8112a
    C28 (net4\#2 VSS!) capacitor c=66.4358a
    C30 (net3 VSS!) capacitor c=63.7518a
    C51 (net3 C) capacitor c=9.12576e-18
    C44 (YN\#2 C) capacitor c=51.7865a
    C45 (YN\#2 C\#2) capacitor c=746.262a
    C46 (YN\#2 C\#3) capacitor c=3.28235e-18
    C49 (C\#4 6) capacitor c=2.16231e-15
    C52 (C\#4 net3) capacitor c=83.616a
    C61 (YN\#2 D\#2) capacitor c=868.45a
    C122 (YN\#2 6) capacitor c=17.0018f
    C132 (net4\#2 6) capacitor c=238.004a
    C133 (net3 6) capacitor c=237.178a
    C3 (VSS!\#1 C\#4) capacitor c=80.641a
    C25 (VSS!\#1 6) capacitor c=12.6505f
    C7 (VSS!\#1 D\#4) capacitor c=75.8965a
    C64 (D\#4 6) capacitor c=1.46412e-15
    C15 (VSS!\#1 Y\#1) capacitor c=109.192a
    C105 (Y\#1 6) capacitor c=1.87602e-15
    C98 (YN Y) capacitor c=408.94a
    C75 (VDD!\#1 YN) capacitor c=30.4104a
    C99 (Y\#2 YN) capacitor c=101.64a
    C106 (Y\#2 X9_5) capacitor c=406.72a
    C82 (VDD!\#1 X9_5) capacitor c=212.366a
    C126 (YN\#2310 X9_5) capacitor c=508.173a
    C81 (VDD!\#2 6) capacitor c=23.9562f
    C21 (VSS!\#1 YN\#2312) capacitor c=187.483a
    C101 (Y\#1 YN\#2312) capacitor c=372.885a
    C121 (YN\#2312 6) capacitor c=3.4178e-15
    C102 (YN\#6 Y\#1) capacitor c=22.809a
    C123 (YN\#2312 net2) capacitor c=1.12473e-18
    C22 (YN\#6 VSS!\#1) capacitor c=91.0597a
    C32 (VSS!\#1 net2) capacitor c=72.6356a
    C34 (net2\#2 VSS!\#1) capacitor c=72.6564a
    C33 (net2\#2 VSS!) capacitor c=1.49571e-18
    C26 (VSS!\#2 6) capacitor c=3.93e-16
    C29 (VSS!\#2 net4\#2) capacitor c=39.1322a
    C53 (net2\#2 C\#4) capacitor c=83.616a
    C138 (net2\#2 net3) capacitor c=39.8112a
    C58 (YN\#6 D) capacitor c=531.598a
    C66 (net2 D) capacitor c=46.786a
    C59 (YN\#6 D\#4) capacitor c=167.909a
    C60 (D\#3 YN\#6) capacitor c=30.4761a
    C68 (D\#3 net2) capacitor c=1.09427e-19
    C67 (D\#4 net2) capacitor c=83.616a
    C124 (YN\#6 net2) capacitor c=46.0379a
    C125 (YN\#2 net2\#2) capacitor c=1.56407e-18
    C135 (net2 6) capacitor c=236.848a
    C136 (net2\#2 6) capacitor c=238.004a
    C94 (A\#4 6) capacitor c=3.47585e-15
    C12 (VSS!\#2 A\#4) capacitor c=187.972a
    C96 (net4\#2 A\#4) capacitor c=83.616a
    C54 (C\#2 X7_5) capacitor c=531.824a
    C78 (VDD!\#7 YN\#8) capacitor c=204.098a
    C84 (VDD!\#7 X7_5) capacitor c=148.996a
    C128 (YN\#8 X7_5) capacitor c=148.996a
    C55 (VDD!\#6 D\#2) capacitor c=234.793a
    C77 (VDD!\#6 YN\#7) capacitor c=202.322a
    C69 (D\#2 X8_5) capacitor c=531.824a
    C83 (VDD!\#6 X8_5) capacitor c=148.996a
    C127 (YN\#7 X8_5) capacitor c=148.996a
    C70 (VDD!\#5 A) capacitor c=21.508a
    C89 (YN\#5 A) capacitor c=206.03a
    C71 (VDD!\#5 A\#2) capacitor c=238.688a
    C72 (A\#3 VDD!\#5) capacitor c=1.36323e-18
    C91 (A\#3 YN\#5) capacitor c=13.0587a
    C80 (VDD!\#5 YN\#5) capacitor c=178.905a
    C90 (YN\#5 A\#2) capacitor c=189.689a
    C97 (A\#2 X5_5) capacitor c=531.582a
    C130 (YN\#5 X5_5) capacitor c=181.705a
    C86 (VDD!\#5 X5_5) capacitor c=437.382a
    C74 (VDD!\#8 B\#4) capacitor c=234.793a
    C79 (VDD!\#8 YN\#9) capacitor c=204.107a
    C85 (VDD!\#8 X6_5) capacitor c=148.996a
    C119 (B\#4 X6_5) capacitor c=531.824a
    C129 (YN\#9 X6_5) capacitor c=148.996a
    MX9_M0_unmatched (Y\#2 YN\#2310 VDD!\#1 VDD!\#1) pch w=4e-06 l=1e-06 \
        as=0 ad=1e-11 ps=0 pd=1.3e-05 sa=2e-06 sb=2e-06
    MX7_M0_unmatched (YN\#8 C\#2 VDD!\#7 VDD!\#7) pch w=4e-06 l=1e-06 as=0 \
        ad=1e-11 ps=0 pd=1.3e-05 sa=2e-06 sb=2e-06
    MX8_M0_unmatched (YN\#7 D\#2 VDD!\#6 VDD!\#6) pch w=4e-06 l=1e-06 as=0 \
        ad=1e-11 ps=0 pd=1.3e-05 sa=2e-06 sb=2e-06
    MX5_M0_unmatched (YN\#5 A\#2 VDD!\#5 VDD!\#5) pch w=4e-06 l=1e-06 as=0 \
        ad=1e-11 ps=0 pd=1.3e-05 sa=2e-06 sb=2e-06
    MX6_M0_unmatched (YN\#9 B\#4 VDD!\#8 VDD!\#8) pch w=4e-06 l=1e-06 as=0 \
        ad=1e-11 ps=0 pd=1.3e-05 sa=2e-06 sb=2e-06
    Rc24 (VDD! VDD!\#5) resistor r=2.6222
    Rc21 (VDD! VDD!\#4) resistor r=66.34m
    Rs1 (6 VSS!) resistor r=50
    Rd13 (C\#2 C\#3) resistor r=1936.0317
    Rd15 (C\#3 C) resistor r=85.564
    Rc13 (D\#2 D\#3) resistor r=2536.0317
    Rc12 (D\#3 D) resistor r=85.564
    Rd7 (A\#2 A\#3) resistor r=736.0318
    Rd9 (A\#3 A) resistor r=85.564
    Rc17 (Y Y\#2) resistor r=2.775
    Rd8 (B\#2 B\#3) resistor r=1636.0317
    Rc9 (B\#2 B\#4) resistor r=1936.0317
    Rc15 (B\#2 B) resistor r=85.564
    Rc5 (net3 net3\#2) resistor r=10.1
    Rc2 (net4 net4\#2) resistor r=10.1
    Rc8 (C\#3 C\#4) resistor r=1636.0317
    Rc18 (YN\#2 YN\#4) resistor r=401.4m
    Rc26 (VSS!\#1 VSS!) resistor r=5.3715
    Rd14 (D\#3 D\#4) resistor r=1036.0317
    Rc16 (Y Y\#1) resistor r=5.4
    Rd10 (YN\#2310 YN\#2311) resistor r=736.0318
    Rd6 (VDD!\#1 VDD!\#2) resistor r=2.6962
    Rd12 (YN\#2311 YN) resistor r=80.464
    Rc10 (YN YN\#2) resistor r=5.093
    Rc11 (YN\#2311 YN\#2312) resistor r=2836.0317
    Rd5 (VDD!\#2 VDD!\#7) resistor r=5.3108
    Rc27 (VSS! VSS!\#2) resistor r=5.0972
    Rc22 (YN\#2 YN\#6) resistor r=5.493
    Rc7 (net2 net2\#2) resistor r=10.1
    Rc14 (A\#3 A\#4) resistor r=2836.0317
    Rc25 (VDD!\#7 VDD!\#4) resistor r=5.3108
    Rd1 (YN\#2 YN\#8) resistor r=5.4316
    Rd3 (YN\#8 YN\#4) resistor r=5.5757
    Rd11 (YN\#2 YN\#7) resistor r=2.668
    Rd4 (VDD!\#2 VDD!\#4) resistor r=133.7m
    Rc19 (VDD!\#2 VDD!\#6) resistor r=2.6224
    Rd2 (YN\#4 YN\#5) resistor r=2.851
    Rc23 (YN\#4 YN\#9) resistor r=2.6545
    Rc20 (VDD!\#4 VDD!\#8) resistor r=2.6224
    MX11_M0_unmatched (net3\#2 B\#3 net4 net4) nch w=2e-06 l=1e-06 as=0 \
        ad=5e-12 ps=0 pd=9e-06 sa=2e-06 sb=2e-06
    MX14_M0_unmatched (Y\#1 YN\#2312 VSS!\#1 VSS!\#1) nch w=2e-06 l=1e-06 \
        as=0 ad=5e-12 ps=0 pd=9e-06 sa=2e-06 sb=2e-06
    MX12_M0_unmatched (net2\#2 C\#4 net3 net3) nch w=2e-06 l=1e-06 as=0 \
        ad=5e-12 ps=0 pd=9e-06 sa=2e-06 sb=2e-06
    MX13_M0_unmatched (YN\#6 D\#4 net2 net2) nch w=2e-06 l=1e-06 as=0 \
        ad=5e-12 ps=0 pd=9e-06 sa=2e-06 sb=2e-06
    MX10_M0_unmatched (net4\#2 A\#4 VSS!\#2 VSS!\#2) nch w=2e-06 l=1e-06 \
        as=0 ad=5e-12 ps=0 pd=9e-06 sa=2e-06 sb=2e-06
ends AND4X1_analog_extracted
// End of subcircuit definition.

// Library name: KISTA_SOI_STDLIB2
// Cell name: OR2X1
// View name: analog_extracted
subckt OR2X1_analog_extracted A B Y
    C1 (Y\#2 VSS!) capacitor c=6.32681e-18
    C3 (VDD!\#1 Y\#2) capacitor c=140.489a
    C9 (Y\#2 YN\#7) capacitor c=257.19a
    C13 (Y\#2 4) capacitor c=1.33433e-15
    C35 (VDD!\#1 VSS!) capacitor c=28.6377a
    C40 (YN\#7 VSS!) capacitor c=1.3598e-19
    C44 (4 VSS!) capacitor c=6.52113e-15
    C51 (VDD!\#1 YN\#7) capacitor c=239.208a
    C55 (VDD!\#1 4) capacitor c=4.88309e-15
    C75 (YN\#7 4) capacitor c=1.25263e-15
    C8 (Y\#2 YN) capacitor c=104.549a
    C74 (4 YN) capacitor c=13.0585f
    C7 (YN Y) capacitor c=414.858a
    C12 (4 Y) capacitor c=2.7658e-15
    C15 (Y\#2 X5_5) capacitor c=406.72a
    C60 (VDD!\#1 X5_5) capacitor c=216.078a
    C80 (YN\#7 X5_5) capacitor c=508.173a
    C4 (B Y) capacitor c=4.82615e-18
    C36 (B VSS!) capacitor c=13.0113a
    C66 (4 B) capacitor c=6.37546e-15
    C6 (B\#3 Y) capacitor c=3.05893e-19
    C14 (Y\#1 4) capacitor c=1.40798e-15
    C39 (B\#3 VSS!) capacitor c=2.32118e-19
    C69 (B\#3 4) capacitor c=356.871a
    C2 (VSS!\#1 Y\#1) capacitor c=109.68a
    C45 (VSS!\#1 4) capacitor c=5.13073e-15
    C5 (Y\#1 B\#4) capacitor c=4.21913e-18
    C68 (B\#4 4) capacitor c=2.63385e-15
    C10 (Y\#1 YN\#9) capacitor c=304.983a
    C41 (VSS!\#1 YN\#9) capacitor c=186.852a
    C11 (YN\#2 Y\#1) capacitor c=15.8784a
    C63 (YN\#2 B) capacitor c=512.296a
    C64 (YN\#2 B\#4) capacitor c=795.246a
    C65 (YN\#2 B\#3) capacitor c=28.7492a
    C76 (YN\#9 4) capacitor c=2.75494e-15
    C77 (YN\#7 net1) capacitor c=1.87456e-18
    C48 (net1 VSS!) capacitor c=3.29987e-19
    C70 (net1 B) capacitor c=7.28235e-18
    C72 (B\#3 net1) capacitor c=4.61573e-19
    C82 (net1 4) capacitor c=142.818a
    C16 (VSS! A) capacitor c=17.6644a
    C22 (B A) capacitor c=9.3594e-18
    C23 (A\#3 B) capacitor c=5.93221e-19
    C20 (A\#3 VSS!) capacitor c=1.06678e-18
    C24 (B\#3 A) capacitor c=5.93221e-19
    C25 (B\#3 A\#3) capacitor c=3.75998e-20
    C29 (4 A) capacitor c=6.69216e-15
    C32 (A\#3 4) capacitor c=381.097a
    C37 (B\#2 VSS!) capacitor c=12.7521a
    C67 (B\#2 4) capacitor c=1.26757e-15
    C71 (B\#2 net1) capacitor c=139.36a
    C17 (A\#2 VSS!) capacitor c=7.45325e-18
    C30 (A\#2 4) capacitor c=2.75126e-15
    C18 (VSS!\#3 A) capacitor c=38.4551a
    C26 (YN\#4 A) capacitor c=109.866a
    C28 (A\#3 YN\#4) capacitor c=3.38863e-18
    C19 (VSS!\#3 A\#4) capacitor c=191.4a
    C27 (YN\#4 A\#4) capacitor c=169.195a
    C31 (A\#4 4) capacitor c=1.44419e-15
    C42 (YN\#4 VSS!) capacitor c=291.881a
    C47 (VSS!\#3 4) capacitor c=3.74752e-15
    C38 (VSS!\#4 B\#4) capacitor c=191.667a
    C43 (YN\#2 VSS!\#4) capacitor c=46.497a
    C46 (VSS!\#4 4) capacitor c=186.083a
    C49 (X4_5 VSS!) capacitor c=6.13238e-18
    C73 (B\#2 X4_5) capacitor c=549.543a
    C84 (X4_5 net1) capacitor c=319.404a
    C81 (YN\#5 X4_5) capacitor c=210.999a
    C53 (YN\#5 VDD!\#1) capacitor c=47.6457a
    C50 (B\#2 VDD!) capacitor c=66.3a
    C52 (YN\#5 VDD!) capacitor c=62.2115a
    C54 (4 VDD!) capacitor c=4.98937e-15
    C57 (net1 VDD!) capacitor c=76.8452a
    C62 (YN\#5 B\#2) capacitor c=258.561a
    C78 (YN\#5 net1) capacitor c=82.8682a
    C33 (net1\#2 A\#2) capacitor c=139.36a
    C58 (net1\#2 VDD!) capacitor c=10.97a
    C21 (VDD!\#2 A\#2) capacitor c=239.793a
    C56 (VDD!\#2 4) capacitor c=4.95426e-15
    C83 (net1\#2 4) capacitor c=79.4518a
    C59 (VDD!\#2 net1\#2) capacitor c=133.602a
    C79 (YN\#4 net1\#2) capacitor c=1.22851e-18
    C34 (A\#2 X3_5) capacitor c=504.174a
    C61 (VDD!\#2 X3_5) capacitor c=486.198a
    C85 (net1\#2 X3_5) capacitor c=319.369a
    MX5_M0_unmatched (Y\#2 YN\#7 VDD!\#1 VDD!\#1) pch w=4e-06 l=1e-06 as=0 \
        ad=1e-11 ps=0 pd=1.3e-05 sa=2e-06 sb=2e-06
    MX4_M0_unmatched (YN\#5 B\#2 net1 net1) pch w=4e-06 l=1e-06 as=0 \
        ad=1e-11 ps=0 pd=1.3e-05 sa=2e-06 sb=2e-06
    MX3_M0_unmatched (net1\#2 A\#2 VDD!\#2 VDD!\#2) pch w=4e-06 l=1e-06 \
        as=0 ad=1e-11 ps=0 pd=1.3e-05 sa=2e-06 sb=2e-06
    Rs1 (4 VSS!) resistor r=50
    Rc10 (Y Y\#2) resistor r=2.875
    Rc9 (Y Y\#1) resistor r=5.3
    Rc5 (B\#3 B) resistor r=85.564
    Rc7 (VSS!\#1 VSS!) resistor r=5.1382
    Rd3 (B\#3 B\#4) resistor r=2236.0317
    Rc1 (YN\#8 YN\#9) resistor r=2236.0317
    Rd2 (YN\#7 YN\#8) resistor r=1336.0317
    Rd4 (YN\#8 YN) resistor r=80.464
    Rc13 (YN YN\#2) resistor r=5.0795
    Rc6 (B\#2 B\#3) resistor r=1336.0317
    Rd9 (A\#3 A) resistor r=85.564
    Rd7 (A\#2 A\#3) resistor r=2536.0317
    Rc4 (A\#3 A\#4) resistor r=1036.0317
    Rd1 (VSS! VSS!\#3) resistor r=5.2316
    Rc8 (VSS!\#4 VSS!\#3) resistor r=808.0294
    Rd8 (VSS! VSS!\#4) resistor r=5.163
    Rc11 (VDD!\#1 VDD!) resistor r=2.6632
    Rd6 (YN\#2 YN\#5) resistor r=2.7731
    Rc3 (net1 net1\#2) resistor r=5.05
    Rc12 (VDD! VDD!\#2) resistor r=2.7238
    Rd5 (YN\#2 YN\#4) resistor r=5.8591
    Rc14 (YN\#2 YN\#6) resistor r=5.6815
    Rc16 (YN\#6 YN\#4) resistor r=100.8539
    MX8_M0_unmatched (Y\#1 YN\#9 VSS!\#1 VSS!\#1) nch w=2e-06 l=1e-06 as=0 \
        ad=5e-12 ps=0 pd=9e-06 sa=2e-06 sb=2e-06
    MX6_M0_unmatched (YN\#4 A\#4 VSS!\#3 VSS!\#3) nch w=2e-06 l=1e-06 as=0 \
        ad=5e-12 ps=0 pd=9e-06 sa=2e-06 sb=2e-06
    MX7_M0_unmatched (YN\#6 B\#4 VSS!\#4 VSS!\#4) nch w=2e-06 l=1e-06 as=0 \
        ad=5e-12 ps=0 pd=9e-06 sa=2e-06 sb=2e-06
ends OR2X1_analog_extracted
// End of subcircuit definition.

// Library name: KISTA_SOI_STDLIB2
// Cell name: OR3X1
// View name: analog_extracted
subckt OR3X1_analog_extracted A B C Y
    C1 (VDD!\#1 Y\#2) capacitor c=140.489a
    C5 (Y\#2 VSS!) capacitor c=6.75928e-18
    C9 (Y\#2 YN\#9) capacitor c=257.19a
    C13 (Y\#2 5) capacitor c=1.33441e-15
    C17 (VDD!\#1 VSS!) capacitor c=28.9781a
    C20 (VDD!\#1 YN\#9) capacitor c=239.208a
    C24 (VDD!\#1 5) capacitor c=4.88359e-15
    C60 (YN\#9 VSS!) capacitor c=8.41163e-20
    C95 (YN\#9 5) capacitor c=1.25261e-15
    C8 (Y\#2 YN) capacitor c=104.584a
    C7 (YN Y) capacitor c=414.858a
    C12 (5 Y) capacitor c=2.7658e-15
    C15 (Y\#2 X7_5) capacitor c=406.72a
    C30 (VDD!\#1 X7_5) capacitor c=216.669a
    C101 (YN\#9 X7_5) capacitor c=508.15a
    C2 (C Y) capacitor c=4.82615e-18
    C33 (VSS! C) capacitor c=18.7112a
    C45 (5 C) capacitor c=6.34044e-15
    C4 (C\#3 Y) capacitor c=3.05893e-19
    C14 (Y\#1 5) capacitor c=1.40798e-15
    C36 (C\#3 VSS!) capacitor c=5.23334e-19
    C48 (C\#3 5) capacitor c=353.334a
    C3 (Y\#1 C\#4) capacitor c=4.21913e-18
    C47 (C\#4 5) capacitor c=2.61035e-15
    C6 (VSS!\#1 Y\#1) capacitor c=109.68a
    C10 (Y\#1 YN\#2311) capacitor c=304.983a
    C61 (VSS!\#1 YN\#2311) capacitor c=186.757a
    C11 (YN\#4 Y\#1) capacitor c=16.4797a
    C44 (YN\#4 C\#4) capacitor c=795.92a
    C96 (YN\#2311 5) capacitor c=2.75493e-15
    C98 (YN\#9 net2) capacitor c=1.87456e-18
    C42 (YN\#2 C) capacitor c=497.258a
    C43 (YN\#2 C\#3) capacitor c=28.8372a
    C49 (net2 C) capacitor c=23.0498a
    C97 (YN\#2 5) capacitor c=14.7507f
    C105 (net2 5) capacitor c=78.2413a
    C22 (YN\#6 VDD!\#1) capacitor c=47.6457a
    C21 (YN\#6 VDD!) capacitor c=62.2115a
    C23 (5 VDD!) capacitor c=7.20132e-15
    C28 (net2 VDD!) capacitor c=76.8452a
    C99 (YN\#6 net2) capacitor c=82.8682a
    C16 (C\#2 VDD!) capacitor c=66.3a
    C34 (C\#2 VSS!) capacitor c=12.6588a
    C41 (YN\#6 C\#2) capacitor c=258.561a
    C46 (C\#2 5) capacitor c=1.26664e-15
    C50 (C\#2 net2) capacitor c=139.36a
    C51 (C\#2 X6_5) capacitor c=548.482a
    C102 (YN\#6 X6_5) capacitor c=210.999a
    C69 (X6_5 VSS!) capacitor c=6.13238e-18
    C110 (X6_5 net2) capacitor c=319.404a
    C29 (net2\#2 VDD!) capacitor c=76.8672a
    C68 (net2\#2 VSS!) capacitor c=2.20455e-18
    C100 (YN\#4 net2\#2) capacitor c=1.22851e-18
    C106 (net2\#2 5) capacitor c=79.4518a
    C19 (B\#2 VDD!) capacitor c=49.7084a
    C57 (B\#2 VSS!) capacitor c=6.53134e-18
    C87 (B\#2 5) capacitor c=1.32933e-15
    C93 (net2\#2 B\#2) capacitor c=139.36a
    C25 (VDD!\#2 5) capacitor c=7.19273e-15
    C31 (X5_5 VDD!) capacitor c=30.6619a
    C94 (B\#2 X5_5) capacitor c=522.333a
    C111 (net2\#2 X5_5) capacitor c=319.404a
    C108 (X5_5 net1) capacitor c=319.404a
    C26 (VDD!\#2 net1) capacitor c=76.8452a
    C67 (net1 VSS!) capacitor c=3.43305e-18
    C91 (B\#2 net1) capacitor c=139.36a
    C103 (net1 5) capacitor c=142.818a
    C107 (net2\#2 net1) capacitor c=79.6223a
    C38 (B\#3 C) capacitor c=1.32925e-18
    C37 (B C) capacitor c=20.9718a
    C39 (C\#3 B) capacitor c=1.32925e-18
    C40 (C\#3 B\#3) capacitor c=8.42507e-20
    C56 (B VSS!) capacitor c=23.5142a
    C59 (B\#3 VSS!) capacitor c=6.58478e-19
    C83 (YN\#2 B\#3) capacitor c=3.18555e-19
    C62 (YN\#7 VSS!) capacitor c=145.957a
    C84 (YN\#4 B) capacitor c=12.9717a
    C86 (5 B) capacitor c=6.82378e-15
    C89 (B\#3 5) capacitor c=375.044a
    C90 (net1 B) capacitor c=7.28235e-18
    C92 (B\#3 net1) capacitor c=4.61573e-19
    C27 (VDD!\#2 net1\#2) capacitor c=144.594a
    C104 (net1\#2 5) capacitor c=79.4518a
    C35 (VSS!\#5 C\#4) capacitor c=189.313a
    C64 (YN\#4 VSS!\#5) capacitor c=61.8814a
    C66 (VSS!\#3 5) capacitor c=20.345f
    C18 (VDD!\#2 A\#2) capacitor c=239.843a
    C52 (A\#2 VSS!) capacitor c=2.99439e-18
    C55 (A\#3 VSS!) capacitor c=1.13189e-18
    C71 (A\#3 B) capacitor c=6.01922e-19
    C70 (B A) capacitor c=9.49668e-18
    C72 (B\#3 A) capacitor c=6.01922e-19
    C73 (B\#3 A\#3) capacitor c=3.81513e-20
    C77 (5 A) capacitor c=6.664e-15
    C78 (A\#2 5) capacitor c=2.74544e-15
    C80 (A\#3 5) capacitor c=379.301a
    C81 (net1\#2 A\#2) capacitor c=139.36a
    C85 (YN\#4 B\#4) capacitor c=716.353a
    C88 (B\#4 5) capacitor c=2.65606e-15
    C79 (A\#4 5) capacitor c=1.44419e-15
    C76 (A\#3 YN\#5) capacitor c=2.96306e-18
    C65 (VSS!\#3 YN\#5) capacitor c=133.401a
    C74 (YN\#5 A) capacitor c=103.152a
    C53 (VSS!\#4 A) capacitor c=57.1151a
    C54 (VSS!\#4 A\#4) capacitor c=191.394a
    C75 (YN\#5 A\#4) capacitor c=169.195a
    C58 (VSS!\#6 B\#4) capacitor c=189.046a
    C63 (VSS!\#6 YN\#8) capacitor c=174.658a
    C32 (VDD!\#2 X4_5) capacitor c=474.675a
    C82 (A\#2 X4_5) capacitor c=502.904a
    C109 (net1\#2 X4_5) capacitor c=319.404a
    MX7_M0_unmatched (Y\#2 YN\#9 VDD!\#1 VDD!\#1) pch w=4e-06 l=1e-06 as=0 \
        ad=1e-11 ps=0 pd=1.3e-05 sa=2e-06 sb=2e-06
    MX6_M0_unmatched (YN\#6 C\#2 net2 net2) pch w=4e-06 l=1e-06 as=0 \
        ad=1e-11 ps=0 pd=1.3e-05 sa=2e-06 sb=2e-06
    MX5_M0_unmatched (net2\#2 B\#2 net1 net1) pch w=4e-06 l=1e-06 as=0 \
        ad=1e-11 ps=0 pd=1.3e-05 sa=2e-06 sb=2e-06
    MX4_M0_unmatched (net1\#2 A\#2 VDD!\#2 VDD!\#2) pch w=4e-06 l=1e-06 \
        as=0 ad=1e-11 ps=0 pd=1.3e-05 sa=2e-06 sb=2e-06
    MX11_M0_unmatched (Y\#1 YN\#2311 VSS!\#1 VSS!\#1) nch w=2e-06 l=1e-06 \
        as=0 ad=5e-12 ps=0 pd=9e-06 sa=2e-06 sb=2e-06
    MX10_M0_unmatched (YN\#7 C\#4 VSS!\#5 VSS!\#5) nch w=2e-06 l=1e-06 \
        as=0 ad=5e-12 ps=0 pd=9e-06 sa=2e-06 sb=2e-06
    MX8_M0_unmatched (YN\#5 A\#4 VSS!\#4 VSS!\#4) nch w=2e-06 l=1e-06 as=0 \
        ad=5e-12 ps=0 pd=9e-06 sa=2e-06 sb=2e-06
    MX9_M0_unmatched (YN\#8 B\#4 VSS!\#6 VSS!\#6) nch w=2e-06 l=1e-06 as=0 \
        ad=5e-12 ps=0 pd=9e-06 sa=2e-06 sb=2e-06
    Rs1 (5 VSS!) resistor r=50
    Rc14 (Y Y\#2) resistor r=2.875
    Rc13 (Y Y\#1) resistor r=5.3
    Rd12 (C\#3 C) resistor r=85.564
    Rc6 (C\#3 C\#4) resistor r=2236.0317
    Rc21 (VSS!\#1 VSS!) resistor r=5.1382
    Rd8 (YN\#2310 YN\#2311) resistor r=2236.0317
    Rc12 (YN\#9 YN\#2310) resistor r=1336.0317
    Rc9 (YN\#2310 YN) resistor r=80.464
    Rd1 (YN YN\#2) resistor r=5.0795
    Rc17 (YN\#2 YN\#4) resistor r=484.1m
    Rc15 (VDD!\#1 VDD!) resistor r=2.6632
    Rc8 (YN\#2 YN\#6) resistor r=2.7731
    Rd10 (C\#2 C\#3) resistor r=1336.0317
    Rc5 (net2 net2\#2) resistor r=5.05
    Rc16 (VDD! VDD!\#2) resistor r=2.7905
    Rd7 (B\#2 B\#3) resistor r=1336.0317
    Rd3 (YN\#2 YN\#7) resistor r=13.8945
    Rc3 (net1 net1\#2) resistor r=5.05
    Rd9 (B\#3 B) resistor r=85.564
    Rd2 (YN\#7 YN\#4) resistor r=8.3333
    Rd6 (VSS! VSS!\#5) resistor r=7.6791
    Rd5 (VSS!\#5 VSS!\#3) resistor r=15.3582
    Rc22 (VSS! VSS!\#3) resistor r=99.44m
    Rc7 (B\#3 B\#4) resistor r=2236.0317
    Rd11 (A\#3 A\#4) resistor r=1036.0317
    Rc10 (A\#2 A\#3) resistor r=2536.0317
    Rc11 (A\#3 A) resistor r=85.564
    Rd4 (YN\#4 YN\#5) resistor r=5.276
    Rc19 (VSS!\#3 VSS!\#4) resistor r=5.1652
    Rc18 (YN\#4 YN\#8) resistor r=5.0795
    Rc20 (VSS!\#3 VSS!\#6) resistor r=5.0974
ends OR3X1_analog_extracted
// End of subcircuit definition.

// Library name: KISTA_SOI_STDLIB2
// Cell name: OR4X1
// View name: analog_extracted
subckt OR4X1_analog_extracted A B C D Y
    Rs1 (6 VSS!) resistor r=50
    Rd13 (C\#2 C\#3) resistor r=1936.0317
    Rd15 (C\#3 C) resistor r=85.564
    Rc13 (D\#2 D\#3) resistor r=1336.0317
    Rc14 (D\#3 D) resistor r=85.564
    Rc8 (C\#3 C\#4) resistor r=1636.0317
    Rc15 (B\#2 B\#4) resistor r=1936.0317
    Rc10 (B\#2 B) resistor r=85.564
    Rc21 (YN\#3 YN\#9) resistor r=9.8566
    Rc22 (YN\#9 YN\#5) resistor r=10.8855
    Rd4 (VSS!\#3 VSS!\#7) resistor r=5.0974
    Rd3 (YN\#3 YN\#5) resistor r=380.7m
    Rd5 (VSS! VSS!\#3) resistor r=99.44m
    Rd1 (YN\#3 YN\#8) resistor r=5.0981
    Rd14 (D\#3 D\#4) resistor r=2236.0317
    Rc18 (Y Y\#2) resistor r=2.875
    Rc17 (Y Y\#1) resistor r=5.3
    Rd10 (YN\#2311 YN\#2312) resistor r=1336.0317
    Rd12 (YN\#2312 YN) resistor r=80.464
    Rc16 (YN\#2312 YN\#2313) resistor r=2236.0317
    Rc11 (YN YN\#3) resistor r=5.9182
    Rc12 (YN YN\#7) resistor r=55.4128
    Rc19 (VDD!\#1 VDD!) resistor r=2.6632
    Rd11 (YN\#7 YN\#3) resistor r=3.2309
    Rc7 (net3 net3\#2) resistor r=5.05
    Rc27 (VSS! VSS!\#6) resistor r=7.6791
    Rc23 (VSS!\#6 VSS!\#3) resistor r=15.3582
    Rc5 (net2 net2\#2) resistor r=5.05
    Rc20 (VDD! VDD!\#2) resistor r=2.8572
    Rd8 (B\#2 B\#3) resistor r=1636.0317
    Rd6 (VSS!\#1 VSS!) resistor r=5.1382
    Rc2 (net1 net1\#2) resistor r=5.05
    Rd7 (A\#2 A\#3) resistor r=3136.0317
    Rd9 (A\#3 A) resistor r=85.564
    Rc9 (A\#3 A\#4) resistor r=436.0318
    Rc26 (YN\#5 YN\#6) resistor r=5.276
    Rd2 (YN\#5 YN\#2310) resistor r=5.0795
    Rc28 (VSS!\#3 VSS!\#8) resistor r=5.2285
    Rc25 (VSS!\#3 VSS!\#5) resistor r=5.2981
    Rc24 (VSS!\#8 VSS!\#5) resistor r=409.146
    C9 (VDD!\#1 VSS!) capacitor c=27.0663a
    C14 (Y\#2 VSS!) capacitor c=6.75928e-18
    C68 (VDD!\#1 Y\#2) capacitor c=140.489a
    C70 (VDD!\#1 YN\#2311) capacitor c=239.208a
    C74 (VDD!\#1 6) capacitor c=4.88359e-15
    C99 (Y\#2 YN\#2311) capacitor c=257.19a
    C103 (Y\#2 6) capacitor c=1.33441e-15
    C119 (YN\#2311 6) capacitor c=1.25263e-15
    C121 (YN\#3 6) capacitor c=16.4712f
    C1 (C VSS!) capacitor c=15.4588a
    C41 (YN\#3 C) capacitor c=20.3632a
    C44 (6 C) capacitor c=6.61902e-15
    C2 (C\#2 VSS!) capacitor c=9.887e-18
    C45 (C\#2 6) capacitor c=2.03836e-15
    C4 (C\#3 VSS!) capacitor c=3.81361e-19
    C43 (YN\#3 C\#3) capacitor c=1.29067e-18
    C47 (C\#3 6) capacitor c=371.049a
    C5 (D VSS!) capacitor c=17.0322a
    C31 (D C) capacitor c=21.7969a
    C32 (C\#3 D) capacitor c=6.38834e-19
    C57 (YN\#3 D) capacitor c=497.272a
    C60 (6 D) capacitor c=6.34812e-15
    C6 (D\#2 VSS!) capacitor c=12.6051a
    C61 (D\#2 6) capacitor c=1.26665e-15
    C8 (D\#3 VSS!) capacitor c=4.04721e-19
    C33 (D\#3 C) capacitor c=1.38154e-18
    C34 (D\#3 C\#3) capacitor c=4.04908e-20
    C59 (YN\#3 D\#3) capacitor c=28.838a
    C63 (D\#3 6) capacitor c=353.825a
    C10 (A\#2 VSS!) capacitor c=2.79565e-18
    C92 (A\#2 6) capacitor c=3.4558e-15
    C16 (B VSS!) capacitor c=8.93241e-19
    C36 (B C) capacitor c=58.3087a
    C38 (C\#3 B) capacitor c=3.69574e-18
    C109 (6 B) capacitor c=955.524a
    C17 (B\#4 VSS!) capacitor c=2.70019e-18
    C110 (B\#4 6) capacitor c=2.04088e-15
    C19 (B\#2 VSS!) capacitor c=17.3354a
    C37 (B\#2 C) capacitor c=25.8323a
    C48 (net2 C) capacitor c=3.17032e-18
    C28 (net2 VSS!) capacitor c=6.15782e-18
    C39 (C\#3 B\#2) capacitor c=1.63731e-18
    C42 (YN\#3 C\#4) capacitor c=711.011a
    C46 (C\#4 6) capacitor c=1.99981e-15
    C49 (C\#2 net2) capacitor c=139.36a
    C112 (B\#2 6) capacitor c=5.81938e-15
    C129 (net2 6) capacitor c=78.5913a
    C3 (VSS!\#7 C\#4) capacitor c=190.211a
    C24 (YN\#5 VSS!\#7) capacitor c=247.509a
    C26 (VSS!\#3 6) capacitor c=25.1058f
    C106 (YN\#5 B) capacitor c=17.4204a
    C108 (YN\#5 B\#2) capacitor c=6.70737e-19
    C21 (YN\#8 VSS!) capacitor c=141.958a
    C7 (VSS!\#6 D\#4) capacitor c=189.216a
    C23 (YN\#3 VSS!\#6) capacitor c=49.2334a
    C58 (YN\#3 D\#4) capacitor c=795.958a
    C62 (D\#4 6) capacitor c=2.64683e-15
    C54 (Y\#1 D\#4) capacitor c=4.21913e-18
    C55 (D\#3 Y) capacitor c=3.05893e-19
    C53 (Y D) capacitor c=4.82615e-18
    C64 (net3 D) capacitor c=23.0498a
    C65 (D\#2 net3) capacitor c=139.36a
    C101 (YN\#3 Y\#1) capacitor c=16.3294a
    C102 (6 Y) capacitor c=2.7658e-15
    C104 (Y\#1 6) capacitor c=1.40798e-15
    C122 (YN\#2311 net3) capacitor c=1.87456e-18
    C131 (net3 6) capacitor c=78.2413a
    C97 (YN Y) capacitor c=414.858a
    C98 (Y\#2 YN) capacitor c=104.584a
    C105 (Y\#2 X9_5) capacitor c=406.72a
    C83 (VDD!\#1 X9_5) capacitor c=216.669a
    C125 (YN\#2311 X9_5) capacitor c=508.173a
    C100 (Y\#1 YN\#2313) capacitor c=304.983a
    C120 (YN\#2313 6) capacitor c=2.75493e-15
    C40 (YN\#7 C\#2) capacitor c=4.08995e-18
    C56 (YN\#7 D\#2) capacitor c=258.561a
    C72 (YN\#7 VDD!\#1) capacitor c=47.6457a
    C35 (C\#2 VDD!) capacitor c=66.3a
    C52 (D\#2 VDD!) capacitor c=66.3a
    C71 (YN\#7 VDD!) capacitor c=62.2115a
    C73 (6 VDD!) capacitor c=9.44224e-15
    C78 (net2 VDD!) capacitor c=76.8452a
    C81 (net3 VDD!) capacitor c=76.8452a
    C123 (YN\#7 net3) capacitor c=82.8682a
    C124 (YN\#3 net3\#2) capacitor c=1.22851e-18
    C29 (net3\#2 VSS!) capacitor c=2.20455e-18
    C50 (net3\#2 C\#2) capacitor c=139.36a
    C82 (net3\#2 VDD!) capacitor c=76.8672a
    C132 (net3\#2 6) capacitor c=79.4518a
    C136 (net3\#2 net2) capacitor c=79.6223a
    C66 (D\#2 X8_5) capacitor c=548.497a
    C126 (YN\#7 X8_5) capacitor c=210.999a
    C139 (X8_5 net3) capacitor c=319.404a
    C30 (X8_5 VSS!) capacitor c=6.13238e-18
    C51 (C\#2 X7_5) capacitor c=521.806a
    C140 (net3\#2 X7_5) capacitor c=319.404a
    C84 (X7_5 VDD!) capacitor c=30.6619a
    C137 (X7_5 net2) capacitor c=319.404a
    C79 (net2\#2 VDD!) capacitor c=10.97a
    C67 (VDD!\#2 A\#2) capacitor c=239.843a
    C69 (VDD!\#2 B\#4) capacitor c=66.1897a
    C75 (VDD!\#2 6) capacitor c=9.28773e-15
    C80 (VDD!\#2 net2\#2) capacitor c=65.8752a
    C115 (net2\#2 B) capacitor c=2.57329e-18
    C116 (net2\#2 B\#4) capacitor c=139.36a
    C117 (B\#2 net2\#2) capacitor c=1.63101e-19
    C107 (YN\#5 B\#3) capacitor c=700.62a
    C111 (B\#3 6) capacitor c=2.01926e-15
    C130 (net2\#2 6) capacitor c=211.296a
    C15 (VSS!\#1 Y\#1) capacitor c=109.68a
    C20 (VSS!\#1 YN\#2313) capacitor c=186.617a
    C27 (net1 VSS!) capacitor c=3.43305e-18
    C76 (VDD!\#2 net1) capacitor c=76.8452a
    C113 (net1 B) capacitor c=2.71536e-18
    C114 (B\#4 net1) capacitor c=139.36a
    C127 (net1 6) capacitor c=79.0526a
    C133 (net2\#2 net1) capacitor c=79.6223a
    C118 (B\#4 X6_5) capacitor c=521.842a
    C138 (net2\#2 X6_5) capacitor c=319.369a
    C134 (X6_5 net1) capacitor c=319.404a
    C77 (VDD!\#2 net1\#2) capacitor c=144.594a
    C95 (net1\#2 A\#2) capacitor c=139.36a
    C128 (net1\#2 6) capacitor c=79.4518a
    C85 (VDD!\#2 X5_5) capacitor c=474.675a
    C135 (net1\#2 X5_5) capacitor c=319.404a
    C96 (A\#2 X5_5) capacitor c=502.953a
    C87 (A\#3 B) capacitor c=6.72e-19
    C86 (B A) capacitor c=10.6023a
    C91 (6 A) capacitor c=6.53409e-15
    C94 (A\#3 6) capacitor c=360.729a
    C93 (A\#4 6) capacitor c=800.282a
    C11 (VSS!\#5 A) capacitor c=68.5671a
    C88 (YN\#6 A) capacitor c=173.614a
    C12 (VSS!\#5 A\#4) capacitor c=191.005a
    C13 (A\#3 VSS!\#5) capacitor c=4.07494e-18
    C90 (A\#3 YN\#6) capacitor c=11.0041a
    C22 (VSS!\#5 YN\#6) capacitor c=138.72a
    C89 (YN\#6 A\#4) capacitor c=101.595a
    C25 (VSS!\#3 YN\#2310) capacitor c=115.581a
    C18 (VSS!\#8 B\#3) capacitor c=190.898a
    MX12_M0_unmatched (YN\#9 C\#4 VSS!\#7 VSS!\#7) nch w=2e-06 l=1e-06 \
        as=0 ad=5e-12 ps=0 pd=9e-06 sa=2e-06 sb=2e-06
    MX13_M0_unmatched (YN\#8 D\#4 VSS!\#6 VSS!\#6) nch w=2e-06 l=1e-06 \
        as=0 ad=5e-12 ps=0 pd=9e-06 sa=2e-06 sb=2e-06
    MX14_M0_unmatched (Y\#1 YN\#2313 VSS!\#1 VSS!\#1) nch w=2e-06 l=1e-06 \
        as=0 ad=5e-12 ps=0 pd=9e-06 sa=2e-06 sb=2e-06
    MX10_M0_unmatched (YN\#6 A\#4 VSS!\#5 VSS!\#5) nch w=2e-06 l=1e-06 \
        as=0 ad=5e-12 ps=0 pd=9e-06 sa=2e-06 sb=2e-06
    MX11_M0_unmatched (YN\#2310 B\#3 VSS!\#8 VSS!\#8) nch w=2e-06 l=1e-06 \
        as=0 ad=5e-12 ps=0 pd=9e-06 sa=2e-06 sb=2e-06
    MX9_M0_unmatched (Y\#2 YN\#2311 VDD!\#1 VDD!\#1) pch w=4e-06 l=1e-06 \
        as=0 ad=1e-11 ps=0 pd=1.3e-05 sa=2e-06 sb=2e-06
    MX8_M0_unmatched (YN\#7 D\#2 net3 net3) pch w=4e-06 l=1e-06 as=0 \
        ad=1e-11 ps=0 pd=1.3e-05 sa=2e-06 sb=2e-06
    MX7_M0_unmatched (net3\#2 C\#2 net2 net2) pch w=4e-06 l=1e-06 as=0 \
        ad=1e-11 ps=0 pd=1.3e-05 sa=2e-06 sb=2e-06
    MX6_M0_unmatched (net2\#2 B\#4 net1 net1) pch w=4e-06 l=1e-06 as=0 \
        ad=1e-11 ps=0 pd=1.3e-05 sa=2e-06 sb=2e-06
    MX5_M0_unmatched (net1\#2 A\#2 VDD!\#2 VDD!\#2) pch w=4e-06 l=1e-06 \
        as=0 ad=1e-11 ps=0 pd=1.3e-05 sa=2e-06 sb=2e-06
ends OR4X1_analog_extracted
// End of subcircuit definition.

// Library name: KISTA_SOI_STDLIB2
// Cell name: AO21X1
// View name: analog_extracted
subckt AO21X1_analog_extracted A B C Y
    C16 (YN\#9 VSS!) capacitor c=1.91396e-18
    C20 (5 VSS!) capacitor c=18.9552f
    C30 (VDD!\#1 Y\#2) capacitor c=100.498a
    C31 (VDD!\#1 YN\#9) capacitor c=185.182a
    C34 (VDD!\#1 5) capacitor c=10.1589f
    C74 (Y\#2 YN\#9) capacitor c=257.19a
    C78 (Y\#2 5) capacitor c=866.025a
    C94 (YN\#9 5) capacitor c=1.29227e-15
    C1 (VDD!\#2 VSS!) capacitor c=11.6613a
    C35 (VDD!\#2 5) capacitor c=531.931a
    C2 (A VSS!) capacitor c=13.3211a
    C53 (5 A) capacitor c=5.74963e-15
    C3 (A\#2 VSS!) capacitor c=6.20121e-18
    C28 (VDD!\#1 A\#2) capacitor c=17.2622a
    C43 (Y\#2 A\#2) capacitor c=3.99364e-18
    C54 (A\#2 5) capacitor c=1.98146e-15
    C5 (A\#3 VSS!) capacitor c=5.46591e-19
    C56 (A\#3 5) capacitor c=322.465a
    C6 (C VSS!) capacitor c=16.5176a
    C66 (5 C) capacitor c=5.911e-15
    C7 (C\#2 VSS!) capacitor c=2.42444e-18
    C29 (VDD!\#2 C\#2) capacitor c=182.208a
    C67 (C\#2 5) capacitor c=2.06525e-15
    C8 (VSS!\#3 C) capacitor c=12.7168a
    C23 (VSS!\#3 5) capacitor c=471.077a
    C9 (VSS!\#3 C\#4) capacitor c=187.562a
    C68 (C\#4 5) capacitor c=1.46592e-15
    C10 (C\#3 VSS!\#3) capacitor c=1.54526e-18
    C19 (YN\#6 VSS!) capacitor c=213.78a
    C63 (YN\#6 C\#4) capacitor c=92.1915a
    C69 (C\#3 5) capacitor c=329.706a
    C64 (YN\#3 C) capacitor c=49.205a
    C65 (YN\#3 C\#3) capacitor c=2.34265e-18
    C51 (YN\#3 A) capacitor c=686.4a
    C52 (YN\#3 A\#3) capacitor c=43.5057a
    C96 (YN\#3 5) capacitor c=14.1282f
    C11 (Y\#1 VSS!) capacitor c=116.807a
    C79 (Y\#1 5) capacitor c=1.69984e-15
    C12 (B VSS!) capacitor c=3.12695e-18
    C46 (B A) capacitor c=119.308a
    C48 (A\#3 B) capacitor c=4.92818e-18
    C83 (YN\#3 B) capacitor c=155.284a
    C85 (5 B) capacitor c=859.781a
    C13 (B\#4 VSS!) capacitor c=15.7577a
    C86 (B\#4 5) capacitor c=2.59533e-15
    C14 (B\#3 VSS!) capacitor c=66.9594a
    C82 (YN\#4 B\#3) capacitor c=104.351a
    C87 (B\#3 5) capacitor c=756.304a
    C15 (B\#2 VSS!) capacitor c=9.93482e-18
    C47 (B\#2 A) capacitor c=30.1242a
    C49 (A\#3 B\#2) capacitor c=4.47782e-20
    C84 (YN\#3 B\#2) capacitor c=802.78a
    C88 (B\#2 5) capacitor c=4.53763e-15
    C89 (net2\#2 B) capacitor c=46.4454a
    C26 (net2\#2 VSS!) capacitor c=73.7811a
    C90 (net2\#2 B\#3) capacitor c=83.616a
    C91 (B\#2 net2\#2) capacitor c=16.0906a
    C98 (YN\#4 net2\#2) capacitor c=50.7435a
    C105 (net2\#2 5) capacitor c=237.325a
    C24 (net2 VSS!) capacitor c=65.8296a
    C57 (net2 A) capacitor c=46.786a
    C42 (Y A) capacitor c=7.05684e-18
    C45 (A\#3 Y) capacitor c=4.47279e-19
    C59 (A\#3 net2) capacitor c=1.09427e-19
    C44 (Y\#1 A\#4) capacitor c=2.84393e-18
    C55 (A\#4 5) capacitor c=1.3945e-15
    C58 (A\#4 net2) capacitor c=83.616a
    C77 (5 Y) capacitor c=2.51087e-15
    C104 (net2 5) capacitor c=236.17a
    C72 (YN Y) capacitor c=385.107a
    C73 (Y\#2 YN) capacitor c=29.0819a
    C80 (Y\#2 X11_5) capacitor c=406.72a
    C39 (VDD!\#1 X11_5) capacitor c=212.366a
    C101 (YN\#9 X11_5) capacitor c=508.173a
    C75 (Y\#1 YN) capacitor c=17.2834a
    C76 (Y\#1 YN\#2311) capacitor c=240.832a
    C17 (VSS!\#1 YN) capacitor c=8.74696e-18
    C18 (VSS!\#1 YN\#2311) capacitor c=189.982a
    C21 (VSS!\#1 5) capacitor c=603.216a
    C95 (YN\#2311 5) capacitor c=2.09605e-15
    C97 (YN\#2311 net2) capacitor c=1.12473e-18
    C4 (VSS!\#4 A\#4) capacitor c=187.91a
    C25 (VSS!\#4 net2) capacitor c=39.1322a
    C22 (VSS!\#4 5) capacitor c=229.155a
    C27 (net3\#4 VSS!) capacitor c=14.9068a
    C92 (net3\#4 B\#4) capacitor c=240.232a
    C107 (net3\#4 5) capacitor c=2.45723e-15
    C32 (YN\#7 VDD!\#1) capacitor c=81.0162a
    C50 (YN\#7 A\#2) capacitor c=331.163a
    C62 (YN\#8 C\#2) capacitor c=19.9912a
    C81 (YN\#8 B\#4) capacitor c=399.369a
    C100 (net3\#4 YN\#8) capacitor c=186.36a
    C93 (B\#4 X9_5) capacitor c=510.168a
    C103 (YN\#8 X9_5) capacitor c=226.143a
    C110 (net3\#4 X9_5) capacitor c=162.469a
    C33 (5 VDD!) capacitor c=10.6076f
    C37 (net3\#4 VDD!) capacitor c=346.851a
    C36 (VDD!\#1 net3) capacitor c=5.90935e-18
    C60 (A\#2 net3) capacitor c=171.272a
    C99 (YN\#7 net3) capacitor c=87.8851a
    C106 (net3 5) capacitor c=287.511a
    C108 (net3\#3 5) capacitor c=1.17642e-15
    C38 (net3\#3 VDD!\#2) capacitor c=124.939a
    C70 (net3\#3 C\#2) capacitor c=168.558a
    C40 (X8_5 VDD!) capacitor c=36.7943a
    C41 (VDD!\#2 X8_5) capacitor c=405.588a
    C71 (C\#2 X8_5) capacitor c=532.553a
    C111 (net3\#3 X8_5) capacitor c=149.036a
    C61 (A\#2 X10_5) capacitor c=533.577a
    C102 (YN\#7 X10_5) capacitor c=188.398a
    C109 (X10_5 net3) capacitor c=162.469a
    MX11_M0_unmatched (Y\#2 YN\#9 VDD!\#1 VDD!\#1) pch w=4e-06 l=1e-06 \
        as=0 ad=1e-11 ps=0 pd=1.3e-05 sa=2e-06 sb=2e-06
    MX9_M0_unmatched (YN\#8 B\#4 net3\#4 net3\#4) pch w=4e-06 l=1e-06 as=0 \
        ad=1e-11 ps=0 pd=1.3e-05 sa=2e-06 sb=2e-06
    MX8_M0_unmatched (net3\#3 C\#2 VDD!\#2 VDD!\#2) pch w=4e-06 l=1e-06 \
        as=0 ad=1e-11 ps=0 pd=1.3e-05 sa=2e-06 sb=2e-06
    MX10_M0_unmatched (YN\#7 A\#2 net3 net3) pch w=4e-06 l=1e-06 as=0 \
        ad=1e-11 ps=0 pd=1.3e-05 sa=2e-06 sb=2e-06
    Rs1 (5 VSS!) resistor r=50
    Rd11 (A\#2 A\#3) resistor r=1936.0317
    Rd7 (A\#3 A) resistor r=85.564
    Rd10 (VSS! VSS!\#3) resistor r=5.0972
    Rd9 (C\#3 C\#4) resistor r=1036.0317
    Rc9 (C\#2 C\#3) resistor r=1936.0317
    Rc14 (C\#3 C) resistor r=85.564
    Rc1 (YN\#3 YN\#6) resistor r=5.7021
    Rc2 (YN\#4 YN\#6) resistor r=95.6457
    Rc6 (YN\#3 YN\#4) resistor r=5.5903
    Rd8 (B\#2 B\#4) resistor r=2536.0317
    Rd1 (B\#2 B) resistor r=85.564
    Rc11 (B\#2 B\#3) resistor r=436.0318
    Rc7 (net2 net2\#2) resistor r=10.1
    Rc13 (A\#3 A\#4) resistor r=1036.0317
    Rc16 (Y Y\#2) resistor r=2.775
    Rc15 (Y Y\#1) resistor r=5.3
    Rd2 (YN\#9 YN\#2310) resistor r=1336.0317
    Rd6 (YN\#2310 YN) resistor r=80.464
    Rc20 (YN\#2310 YN\#2311) resistor r=1636.0317
    Rc8 (VSS! VSS!\#1) resistor r=5.4718
    Rd12 (VSS!\#1 VSS!\#4) resistor r=167.6845
    Rc12 (VSS! VSS!\#4) resistor r=5.4288
    Rc22 (YN YN\#3) resistor r=5.8896
    Rc19 (YN YN\#7) resistor r=58.4337
    Rd5 (YN\#7 YN\#3) resistor r=3.1822
    Rd4 (YN\#3 YN\#8) resistor r=2.7731
    Rc17 (VDD!\#1 VDD!) resistor r=2.9298
    Rd3 (net3 net3\#3) resistor r=8.4068
    Rc18 (VDD! VDD!\#2) resistor r=2.7222
    Rc21 (net3\#4 net3\#3) resistor r=8.1065
    Rc10 (net3 net3\#4) resistor r=7.8171
    MX4_M0_unmatched (YN\#6 C\#4 VSS!\#3 VSS!\#3) nch w=2e-06 l=1e-06 as=0 \
        ad=5e-12 ps=0 pd=9e-06 sa=2e-06 sb=2e-06
    MX5_M0_unmatched (YN\#4 B\#3 net2\#2 net2\#2) nch w=2e-06 l=1e-06 as=0 \
        ad=5e-12 ps=0 pd=9e-06 sa=2e-06 sb=2e-06
    MX7_M0_unmatched (Y\#1 YN\#2311 VSS!\#1 VSS!\#1) nch w=2e-06 l=1e-06 \
        as=0 ad=5e-12 ps=0 pd=9e-06 sa=2e-06 sb=2e-06
    MX6_M0_unmatched (net2 A\#4 VSS!\#4 VSS!\#4) nch w=2e-06 l=1e-06 as=0 \
        ad=5e-12 ps=0 pd=9e-06 sa=2e-06 sb=2e-06
ends AO21X1_analog_extracted
// End of subcircuit definition.

// Library name: KISTA_SOI_STDLIB2
// Cell name: OA21X1
// View name: analog_extracted
subckt OA21X1_analog_extracted A B C Y
    C1 (VDD!\#1 VSS!) capacitor c=33.2411a
    C18 (YN\#9 VSS!) capacitor c=3.75903e-18
    C20 (5 VSS!) capacitor c=13.4398f
    C28 (VDD!\#1 Y\#2) capacitor c=140.489a
    C30 (VDD!\#1 YN\#9) capacitor c=238.604a
    C33 (VDD!\#1 5) capacitor c=359.739a
    C75 (Y\#2 YN\#9) capacitor c=260.136a
    C79 (Y\#2 5) capacitor c=1.06632e-15
    C96 (YN\#9 5) capacitor c=1.25461e-15
    C2 (A VSS!) capacitor c=7.9093e-18
    C52 (5 A) capacitor c=939.514a
    C3 (A\#4 VSS!) capacitor c=5.75886e-18
    C44 (Y\#2 A\#4) capacitor c=4.49653e-18
    C53 (A\#4 5) capacitor c=2.04751e-15
    C4 (A\#3 VSS!) capacitor c=11.624a
    C54 (A\#3 5) capacitor c=1.41954e-15
    C5 (A\#2 VSS!) capacitor c=12.4454a
    C55 (A\#2 5) capacitor c=5.00228e-15
    C6 (C VSS!) capacitor c=6.13667e-18
    C67 (5 C) capacitor c=5.93433e-15
    C7 (C\#2 VSS!) capacitor c=5.24461e-18
    C68 (C\#2 5) capacitor c=2.0284e-15
    C8 (VSS!\#2 C) capacitor c=13.617a
    C22 (VSS!\#2 5) capacitor c=7.43977e-15
    C9 (VSS!\#2 C\#4) capacitor c=126.301a
    C69 (C\#4 5) capacitor c=1.47218e-15
    C10 (C\#3 VSS!\#2) capacitor c=9.82844e-19
    C70 (C\#3 5) capacitor c=330.953a
    C11 (Y VSS!) capacitor c=5.80631e-18
    C43 (Y A) capacitor c=7.77555e-18
    C46 (A\#2 Y) capacitor c=8.05363e-18
    C51 (YN\#2 A\#2) capacitor c=638.594a
    C65 (YN\#2 C) capacitor c=32.3055a
    C66 (YN\#2 C\#3) capacitor c=1.11276e-18
    C78 (5 Y) capacitor c=2.53057e-15
    C13 (B VSS!) capacitor c=12.9263a
    C60 (B C) capacitor c=25.1522a
    C62 (B\#3 C) capacitor c=4.73762e-19
    C16 (B\#3 VSS!) capacitor c=7.37463e-19
    C61 (C\#3 B) capacitor c=1.59421e-18
    C63 (B\#3 C\#3) capacitor c=3.00281e-20
    C84 (YN\#2 B) capacitor c=971.921a
    C85 (YN\#2 B\#3) capacitor c=56.2141a
    C86 (5 B) capacitor c=5.29848e-15
    C89 (B\#3 5) capacitor c=301.166a
    C91 (net2\#2 B) capacitor c=54.112a
    C93 (B\#3 net2\#2) capacitor c=3.42975e-18
    C109 (net2\#2 5) capacitor c=2.20951e-15
    C14 (B\#2 VSS!) capacitor c=4.93082e-18
    C87 (B\#2 5) capacitor c=2.5782e-15
    C15 (B\#4 VSS!) capacitor c=7.14554e-18
    C88 (B\#4 5) capacitor c=762.204a
    C92 (net2\#2 B\#4) capacitor c=184.144a
    C17 (YN VSS!) capacitor c=41.2376a
    C47 (YN A) capacitor c=81.1723a
    C73 (YN Y) capacitor c=378.726a
    C45 (Y\#1 A) capacitor c=11.9801a
    C74 (Y\#2 YN) capacitor c=17.3182a
    C81 (Y\#2 X7_5) capacitor c=450.085a
    C40 (VDD!\#1 X7_5) capacitor c=175.347a
    C29 (B\#2 VDD!) capacitor c=63.5259a
    C32 (5 VDD!) capacitor c=12.2636f
    C39 (X7_5 VDD!) capacitor c=30.6619a
    C103 (YN\#9 X7_5) capacitor c=508.67a
    C76 (Y\#1 YN) capacitor c=16.9161a
    C80 (Y\#1 5) capacitor c=1.48395e-15
    C95 (5 YN) capacitor c=12.6984f
    C98 (YN\#9 net1) capacitor c=1.87456e-18
    C36 (net1 VDD!) capacitor c=68.6095a
    C48 (YN\#2311 A) capacitor c=7.13252e-18
    C57 (net2 A) capacitor c=32.8495a
    C24 (net2 VSS!) capacitor c=375.6a
    C56 (A\#4 net1) capacitor c=139.36a
    C58 (A\#3 net2) capacitor c=181.404a
    C77 (Y\#1 YN\#2311) capacitor c=224.754a
    C97 (YN\#2311 5) capacitor c=2.11453e-15
    C100 (YN\#2 net1) capacitor c=5.52053e-18
    C106 (net1 5) capacitor c=78.8258a
    C108 (net2 5) capacitor c=1.99549e-15
    C12 (VSS!\#1 Y\#1) capacitor c=71.7835a
    C19 (VSS!\#1 YN\#2311) capacitor c=135.116a
    C21 (VSS!\#1 5) capacitor c=1.1911e-15
    C23 (net1\#2 VSS!) capacitor c=1.87456e-18
    C38 (net1\#2 VDD!) capacitor c=76.8672a
    C90 (net1\#2 B\#2) capacitor c=139.36a
    C107 (net1\#2 5) capacitor c=79.2239a
    C25 (VSS!\#2 net2\#4) capacitor c=100.122a
    C71 (net2\#4 C\#4) capacitor c=84.7237a
    C110 (net2\#4 5) capacitor c=251.655a
    C26 (VDD!\#3 A\#4) capacitor c=235.79a
    C34 (VDD!\#3 5) capacitor c=44.6689a
    C35 (VDD!\#2 5) capacitor c=6.76432e-15
    C27 (VDD!\#2 C\#2) capacitor c=239.793a
    C37 (VDD!\#3 net1) capacitor c=75.9625a
    C41 (VDD!\#3 X6_5) capacitor c=183.465a
    C111 (X6_5 net1) capacitor c=318.488a
    C59 (A\#4 X6_5) capacitor c=528.626a
    C50 (YN\#3 A\#4) capacitor c=5.57746e-18
    C82 (YN\#3 B\#2) capacitor c=388.786a
    C99 (YN\#3 net1\#2) capacitor c=96.3644a
    C94 (B\#2 X5_5) capacitor c=505.217a
    C112 (net1\#2 X5_5) capacitor c=318.488a
    C104 (YN\#3 X5_5) capacitor c=502.728a
    C31 (YN\#5 VDD!\#2) capacitor c=212.138a
    C64 (YN\#5 C\#2) capacitor c=154.672a
    C42 (VDD!\#2 X4_5) capacitor c=480.747a
    C72 (C\#2 X4_5) capacitor c=503.077a
    C105 (YN\#5 X4_5) capacitor c=319.404a
    C49 (YN\#8 A\#3) capacitor c=90.6085a
    C101 (YN\#8 net2) capacitor c=100.266a
    C83 (YN\#6 B\#4) capacitor c=104.384a
    C102 (YN\#6 net2\#2) capacitor c=119.21a
    MX11_M0_unmatched (Y\#1 YN\#2311 VSS!\#1 VSS!\#1) nch w=2e-06 l=1e-06 \
        as=0 ad=5e-12 ps=0 pd=9e-06 sa=2e-06 sb=2e-06
    MX8_M0_unmatched (net2\#4 C\#4 VSS!\#2 VSS!\#2) nch w=2e-06 l=1e-06 \
        as=0 ad=5e-12 ps=0 pd=9e-06 sa=2e-06 sb=2e-06
    MX10_M0_unmatched (YN\#8 A\#3 net2 net2) nch w=2e-06 l=1e-06 as=0 \
        ad=5e-12 ps=0 pd=9e-06 sa=2e-06 sb=2e-06
    MX9_M0_unmatched (YN\#6 B\#4 net2\#2 net2\#2) nch w=2e-06 l=1e-06 as=0 \
        ad=5e-12 ps=0 pd=9e-06 sa=2e-06 sb=2e-06
    Rs1 (5 VSS!) resistor r=50
    Rd10 (A\#2 A\#4) resistor r=1936.0317
    Rd12 (A\#2 A) resistor r=85.564
    Rc8 (A\#2 A\#3) resistor r=1036.0317
    Rc21 (VSS! VSS!\#2) resistor r=5.3655
    Rd11 (C\#3 C\#4) resistor r=1036.0317
    Rc13 (C\#2 C\#3) resistor r=1936.0317
    Rc10 (C\#3 C) resistor r=85.564
    Rc16 (Y Y\#2) resistor r=2.775
    Rd8 (B\#3 B) resistor r=85.564
    Rd9 (B\#2 B\#3) resistor r=2536.0317
    Rc9 (B\#3 B\#4) resistor r=436.0318
    Rc15 (Y Y\#1) resistor r=5.3
    Rc17 (VDD!\#1 VDD!) resistor r=2.6632
    Rc4 (YN YN\#2) resistor r=5.2981
    Rd3 (YN\#2310 YN) resistor r=80.464
    Rd1 (YN\#9 YN\#2310) resistor r=1336.0317
    Rc11 (YN\#2310 YN\#2311) resistor r=1636.0317
    Rc12 (net2 net2\#2) resistor r=15.8048
    Rc20 (VSS!\#1 VSS!) resistor r=5.2382
    Rc3 (net1 net1\#2) resistor r=5.05
    Rd7 (net2 net2\#4) resistor r=16.1209
    Rc14 (net2\#2 net2\#4) resistor r=14.7739
    Rc19 (VDD! VDD!\#3) resistor r=2.6083
    Rc18 (VDD! VDD!\#2) resistor r=2.7905
    Rd2 (YN\#2 YN\#3) resistor r=3.1952
    Rd4 (YN\#3 YN\#5) resistor r=23.2112
    Rc1 (YN\#2 YN\#5) resistor r=3.2591
    Rc2 (YN\#2 YN\#8) resistor r=5.6647
    Rd6 (YN\#2 YN\#6) resistor r=5.5536
    Rc5 (YN\#8 YN\#6) resistor r=101.3195
    MX7_M0_unmatched (Y\#2 YN\#9 VDD!\#1 VDD!\#1) pch w=4e-06 l=1e-06 as=0 \
        ad=1e-11 ps=0 pd=1.3e-05 sa=2e-06 sb=2e-06
    MX6_M0_unmatched (net1 A\#4 VDD!\#3 VDD!\#3) pch w=4e-06 l=1e-06 as=0 \
        ad=1e-11 ps=0 pd=1.3e-05 sa=2e-06 sb=2e-06
    MX5_M0_unmatched (YN\#3 B\#2 net1\#2 net1\#2) pch w=4e-06 l=1e-06 as=0 \
        ad=1e-11 ps=0 pd=1.3e-05 sa=2e-06 sb=2e-06
    MX4_M0_unmatched (YN\#5 C\#2 VDD!\#2 VDD!\#2) pch w=4e-06 l=1e-06 as=0 \
        ad=1e-11 ps=0 pd=1.3e-05 sa=2e-06 sb=2e-06
ends OA21X1_analog_extracted
// End of subcircuit definition.

// Library name: KISTA_SOI_STDLIB2
// Cell name: ADDFX1
// View name: analog_extracted
subckt ADDFX1_analog_extracted A B CIN COUT SUM
    Rc80 (coutn\#2314 coutn\#2315) resistor r=300
    Rc81 (coutn\#2315 coutn\#2310) resistor r=436.0318
    Rd22 (CIN\#6 CIN\#4) resistor r=6.5871
    Rs1 (7 VSS!) resistor r=50
    Rc54 (sumn\#5 sumn\#8) resistor r=2.668
    Rc52 (sumn\#2310 sumn\#2311) resistor r=736.0318
    Rc50 (sumn\#2311 sumn\#5) resistor r=85.557
    Rc71 (VDD!\#5 VDD!\#9) resistor r=2.7345
    Rd25 (coutn coutn\#2310) resistor r=85.764
    Rc70 (VDD!\#5 VDD!\#2311) resistor r=2.9839
    Rc51 (VDD!\#9 VDD!\#2311) resistor r=60.9516
    Rd8 (coutn coutn\#9) resistor r=2.6741
    Rc22 (net38 net38\#2) resistor r=22.075
    Rc26 (net38 net38\#5) resistor r=3.532
    Rc23 (net38\#2 net38\#5) resistor r=3.2704
    Rd38 (VDD!\#1 VDD!\#2) resistor r=2.8705
    Rc61 (SUM SUM\#2) resistor r=2.675
    Rc49 (sumn\#2311 sumn\#2312) resistor r=2836.0317
    Rc30 (CIN\#2310 CIN\#2311) resistor r=1336.0317
    Rc60 (SUM SUM\#1) resistor r=5.5
    Rc47 (net39 net39\#2) resistor r=5.1779
    Rd17 (CIN\#4 CIN\#2311) resistor r=113.3832
    Rc89 (CIN\#6 CIN\#2311) resistor r=377.9439
    Rc46 (net43 net43\#2) resistor r=5.2
    Rd13 (B\#2311 B\#9) resistor r=32.1385
    Rd21 (B\#9 B\#7) resistor r=7.4607
    Rc78 (B\#2311 B\#7) resistor r=8.356
    Rd1 (CIN\#4 CIN) resistor r=0.1
    Rc84 (B\#7 B) resistor r=0.1
    Rc31 (CIN\#2 CIN) resistor r=0.1
    Rd7 (coutn coutn\#8) resistor r=2.8404
    Rc76 (coutn\#9 coutn\#8) resistor r=102.4616
    Rd11 (CIN\#6 CIN\#7) resistor r=1583.8093
    Rc63 (VDD!\#2 VDD!\#6) resistor r=2.5488
    Rc59 (net47 net47\#2) resistor r=38.95
    Rc55 (net47\#2 net47\#5) resistor r=2.8852
    Rc43 (A\#2312 A\#2315) resistor r=2783.8093
    Rc33 (net47 net47\#5) resistor r=3.116
    Rd14 (B\#2311 B\#2314) resistor r=2183.8093
    Rc79 (B\#9 B\#2310) resistor r=2183.8093
    Rd15 (VDD!\#2 VDD!\#7) resistor r=5.1621
    Rc69 (VDD!\#2 VDD!\#4) resistor r=130.8m
    Rc64 (VDD!\#7 VDD!\#4) resistor r=5.1621
    Rc73 (VDD!\#4 VDD!\#5) resistor r=223.6m
    Rc65 (VDD! VDD!\#5) resistor r=366.3m
    Rd31 (coutn\#2313 coutn\#2314) resistor r=3017.6187
    Rd24 (coutn\#2311 coutn\#2310) resistor r=2836.0317
    Rc56 (sumn\#5 sumn\#9) resistor r=38.1791
    Rc68 (VDD! VDD!\#2312) resistor r=2.8002
    Rc27 (net38\#5 net38\#4) resistor r=2.5
    Rc25 (net38\#5 net38\#6) resistor r=2.7
    Rc37 (net47\#5 net47\#4) resistor r=2.5
    Rc19 (sumn sumn\#5) resistor r=1.4378
    Rc58 (sumn\#5 sumn\#7) resistor r=5.493
    Rc57 (sumn sumn\#9) resistor r=2.9005
    Rc66 (VDD!\#4 VDD!\#8) resistor r=2.5488
    Rc34 (net47\#5 net47\#8) resistor r=3.0755
    Rc38 (net47\#5 net47\#6) resistor r=2.8878
    Rc53 (sumn sumn\#3) resistor r=1150.953
    Rc39 (net47\#6 net47\#8) resistor r=38.4437
    Rd34 (A\#2310 A\#2311) resistor r=2783.8093
    Rc40 (A\#2312 A\#2310) resistor r=53.6769
    Rc74 (coutn\#2313 coutn\#2312) resistor r=2700
    Rd30 (coutn\#2312 coutn\#2311) resistor r=3317.6187
    Rd35 (A\#6 A\#8) resistor r=2756.5518
    Rc87 (CIN\#3 CIN\#4) resistor r=1653.2665
    Rc4 (net37 net37\#2) resistor r=5.2
    Rd18 (CIN\#1 CIN\#2) resistor r=2253.2666
    Rc88 (B\#6 B\#7) resistor r=1653.2665
    Rd39 (A\#2 A) resistor r=83.7573
    Rd23 (CIN\#2311 CIN\#2312) resistor r=2236.0317
    Rc86 (CIN\#6 CIN\#5) resistor r=2242.8401
    Rc14 (VSS!\#1 VSS!\#2) resistor r=5.2712
    Rc48 (net5 net5\#2) resistor r=10.1
    Rd12 (B\#9 B\#8) resistor r=1642.84
    Rc5 (VSS!\#2 VSS!\#8) resistor r=10.2608
    Rd5 (A\#2312 A\#2314) resistor r=1042.8398
    Rc41 (A\#2 A\#4) resistor r=956.5518
    Rd6 (coutn coutn\#5) resistor r=2342.9441
    Rc75 (coutn coutn\#3) resistor r=2252.8311
    Rc82 (coutn\#3 coutn\#5) resistor r=10.2227
    Rd28 (VSS! VSS!\#2316) resistor r=5.7614
    Rc7 (VSS!\#8 VSS!\#4) resistor r=10.2608
    Rc77 (B\#2311 B\#2313) resistor r=1642.84
    Rd36 (A\#1 A\#2) resistor r=2141.092
    Rd19 (B\#3 B) resistor r=123.364
    Rd20 (B\#2 B\#3) resistor r=2244.8411
    Rc83 (B\#1 B\#2) resistor r=600
    Rd33 (COUT\#3 COUT\#4) resistor r=96701.1562
    Rc28 (COUT\#3 COUT) resistor r=1934.0231
    Rd37 (A\#2312 A\#5) resistor r=6.978
    Rc85 (B\#3 B\#4) resistor r=1644.8412
    Rc42 (VSS! VSS!\#2314) resistor r=5.5398
    Rd10 (VSS!\#2316 VSS!\#2314) resistor r=104.6865
    Rc45 (net9 net9\#2) resistor r=10.2
    Rd26 (VSS!\#2 VSS!\#7) resistor r=5.0974
    Rd9 (VSS!\#2 VSS!\#4) resistor r=132.9m
    Rd3 (VSS!\#4 VSS!\#6) resistor r=301.7m
    Rd4 (VSS!\#6 VSS!) resistor r=366.3m
    Rc20 (net20\#5 net20\#6) resistor r=5.2
    Rd29 (VSS!\#6 VSS!\#2313) resistor r=5.4781
    Rc67 (A\#5 A) resistor r=0.55
    Rd27 (net3\#2 net3\#4) resistor r=15.2
    Rd32 (net3 net3\#2) resistor r=15.2
    Rc29 (net3 net3\#4) resistor r=15.808
    Rc8 (net1 net1\#2) resistor r=10.2
    Rc17 (VSS!\#6 VSS!\#2311) resistor r=5.1896
    Rc16 (VSS!\#2311 VSS!\#2313) resistor r=281.2561
    Rc15 (VSS!\#2310 VSS!\#6) resistor r=23.2984
    Rc32 (COUT COUT\#4) resistor r=5.1003
    Rc6 (VSS!\#4 VSS!\#2310) resistor r=6.6095
    Rd2 (VSS!\#4 VSS!\#9) resistor r=5.0974
    Rc35 (net20\#2 net20\#5) resistor r=5.3923
    Rc36 (net20 net20\#2) resistor r=140.2
    Rc18 (net20 net20\#5) resistor r=5.608
    Rc21 (net20\#5 net20\#4) resistor r=5
    Rc72 (A\#6 A\#7) resistor r=1115.8707
    Rd16 (A\#6 A\#5) resistor r=83.4573
    Rc62 (A\#2310 A\#5) resistor r=6.2304
    Rc44 (A\#2310 A\#9) resistor r=1042.8398
    C111 (net9\#2 CIN\#5) capacitor c=2.70201e-18
    C180 (net9\#2 B\#2311) capacitor c=23.4863a
    C7 (VDD!\#1 SUM\#2) capacitor c=140.489a
    C16 (VDD!\#1 sumn\#2310) capacitor c=239.208a
    C18 (sumn\#5 VDD!\#1) capacitor c=28.6001a
    C62 (CIN\#6 VSS!) capacitor c=7.79155e-18
    C63 (CIN\#4 VSS!) capacitor c=12.0625a
    C93 (sumn\#5 CIN\#4) capacitor c=897.75a
    C102 (CIN\#6 7) capacitor c=13.9787f
    C103 (CIN\#4 7) capacitor c=13.5897f
    C197 (SUM\#2 VSS!) capacitor c=4.9094e-18
    C225 (sumn\#2310 VSS!) capacitor c=7.12066e-20
    C261 (SUM\#2 sumn\#2310) capacitor c=189.321a
    C265 (sumn\#5 SUM\#2) capacitor c=21.9918a
    C268 (SUM\#2 7) capacitor c=397.718a
    C345 (sumn\#2310 7) capacitor c=587.831a
    C347 (sumn\#5 7) capacitor c=31.7631f
    C1 (VDD!\#1 CIN\#2310) capacitor c=70.3459a
    C58 (CIN\#2310 VSS!) capacitor c=7.98513e-18
    C96 (CIN\#2310 7) capacitor c=1.23115e-15
    C5 (VDD!\#5 VSS!) capacitor c=82.8551a
    C21 (VDD!\#5 7) capacitor c=73.8853f
    C6 (VDD!\#5 COUT\#3) capacitor c=241.581a
    C68 (COUT\#3 CIN\#4) capacitor c=1.06615e-15
    C194 (COUT\#3 VSS!) capacitor c=37.2264a
    C257 (COUT\#3 7) capacitor c=75.0889a
    C15 (VDD!\#5 coutn\#2314) capacitor c=983.56a
    C218 (coutn\#2314 VSS!) capacitor c=6.22162e-18
    C252 (COUT\#3 coutn\#2314) capacitor c=214.094a
    C321 (coutn\#2314 7) capacitor c=2.91194e-15
    C17 (sumn\#8 VDD!\#1) capacitor c=109.857a
    C91 (sumn\#8 CIN\#2310) capacitor c=239.641a
    C19 (sumn\#2311 VDD!\#1) capacitor c=1.81026e-18
    C228 (sumn\#2311 VSS!) capacitor c=3.47833e-19
    C348 (sumn\#2311 7) capacitor c=343.358a
    C26 (VDD!\#5 net38) capacitor c=125.051a
    C242 (net38 VSS!) capacitor c=13.6852a
    C22 (VDD!\#9 net38) capacitor c=25.8973a
    C11 (VDD!\#9 coutn) capacitor c=288.12a
    C85 (CIN\#4 coutn) capacitor c=2.66198e-15
    C216 (coutn VSS!) capacitor c=83.4904a
    C251 (COUT\#3 coutn) capacitor c=17.3317a
    C319 (7 coutn) capacitor c=19.2696f
    C333 (net38 coutn) capacitor c=5.69258e-18
    C13 (coutn\#2310 VDD!\#9) capacitor c=14.6018a
    C89 (coutn\#2310 CIN\#4) capacitor c=45.6829a
    C221 (coutn\#2310 VSS!) capacitor c=6.13314e-19
    C253 (coutn\#2310 COUT\#3) capacitor c=1.14161e-18
    C328 (coutn\#2310 7) capacitor c=424.774a
    C23 (VDD!\#2311 net38) capacitor c=84.6238a
    C42 (VDD!\#9 X40_5) capacitor c=367.496a
    C260 (COUT\#3 X40_5) capacitor c=301.865a
    C338 (X40_5 coutn) capacitor c=243.579a
    C339 (coutn\#2314 X40_5) capacitor c=261.718a
    C340 (coutn\#2310 X40_5) capacitor c=16.044a
    C9 (VDD!\#2311 A\#8) capacitor c=694.926a
    C202 (A\#8 VSS!) capacitor c=9.29154e-18
    C271 (A\#8 coutn) capacitor c=543.55a
    C277 (coutn\#2310 A\#8) capacitor c=35.8025a
    C285 (A\#8 7) capacitor c=2.92893e-15
    C306 (A\#8 net38) capacitor c=171.272a
    C12 (coutn\#9 VDD!\#2311) capacitor c=20.1566a
    C43 (VDD!\#2311 X39_5) capacitor c=161.018a
    C314 (A\#8 X39_5) capacitor c=528.653a
    C324 (coutn\#9 7) capacitor c=79.2399a
    C341 (coutn\#9 X39_5) capacitor c=45.3289a
    C389 (X39_5 net38) capacitor c=152.718a
    C27 (VDD!\#5 net38\#2) capacitor c=204.923a
    C334 (net38\#2 coutn\#9) capacitor c=114.151a
    C36 (VDD!\#1 net39) capacitor c=72.8517a
    C121 (CIN\#2310 net39) capacitor c=198.473a
    C122 (CIN\#6 net39) capacitor c=5.26537e-19
    C123 (CIN\#4 net39) capacitor c=1.78571e-18
    C246 (net39 VSS!) capacitor c=3.78247e-18
    C360 (sumn\#2310 net39) capacitor c=1.96616e-18
    C363 (sumn\#2310 X48_5) capacitor c=508.154a
    C37 (VDD!\#1 X48_5) capacitor c=216.669a
    C270 (SUM\#2 X48_5) capacitor c=406.72a
    C69 (CIN\#6 SUM) capacitor c=1.31569e-18
    C70 (CIN\#4 SUM) capacitor c=4.46208e-18
    C264 (sumn\#5 SUM) capacitor c=444.762a
    C266 (sumn\#2311 SUM) capacitor c=28.3946a
    C267 (7 SUM) capacitor c=2.7654e-15
    C346 (sumn\#2312 7) capacitor c=3.41784e-15
    C361 (sumn\#8 net39) capacitor c=152.184a
    C382 (net39 7) capacitor c=433.413a
    C364 (sumn\#8 X47_5) capacitor c=149.036a
    C125 (CIN\#2310 X47_5) capacitor c=534.803a
    C405 (X47_5 net39) capacitor c=194.872a
    C67 (CIN\#2311 VSS!) capacitor c=3.64765e-19
    C72 (CIN\#2311 SUM) capacitor c=4.02112e-19
    C94 (sumn\#5 CIN\#2311) capacitor c=97.9599a
    C105 (CIN\#2311 7) capacitor c=600.375a
    C124 (CIN\#2311 net39) capacitor c=1.60924e-19
    C262 (SUM\#1 sumn\#2312) capacitor c=372.919a
    C269 (SUM\#1 7) capacitor c=2.34459e-15
    C362 (sumn\#5 net39\#2) capacitor c=98.7284a
    C383 (net39\#2 7) capacitor c=40.547a
    C10 (VDD!\#2 A\#2315) capacitor c=14.2222a
    C200 (A\#2315 VSS!) capacitor c=3.12185e-18
    C281 (sumn\#5 A\#2315) capacitor c=604.18a
    C283 (A\#2315 7) capacitor c=2.88509e-15
    C32 (VDD!\#2 net47) capacitor c=7.15979e-18
    C309 (A\#2315 net47) capacitor c=655.272a
    C357 (sumn\#5 net47) capacitor c=117.138a
    C396 (net39\#2 net47) capacitor c=17.5562a
    C34 (VDD!\#2 net43) capacitor c=123.765a
    C245 (net43 VSS!) capacitor c=3.55811e-18
    C380 (net43 7) capacitor c=220.534a
    C402 (net39\#2 net43) capacitor c=110.029a
    C35 (VDD!\#2 net43\#2) capacitor c=146.453a
    C311 (net43\#2 A\#2315) capacitor c=171.272a
    C359 (sumn\#5 net43\#2) capacitor c=11.2416a
    C381 (net43\#2 7) capacitor c=273.215a
    C395 (net43\#2 net47) capacitor c=84.6238a
    C404 (net43\#2 X45_5) capacitor c=152.718a
    C312 (A\#2315 X45_5) capacitor c=528.653a
    C397 (X45_5 net47) capacitor c=161.018a
    C50 (CIN\#6 B\#2311) capacitor c=297.188a
    C52 (CIN\#4 B\#2311) capacitor c=516.613a
    C56 (CIN\#2311 B\#2311) capacitor c=56.3713a
    C132 (B\#2311 VSS!) capacitor c=7.07654e-18
    C162 (sumn\#5 B\#2311) capacitor c=256.183a
    C172 (B\#2311 7) capacitor c=7.67894e-15
    C51 (B\#9 CIN\#6) capacitor c=1.84976e-15
    C53 (CIN\#4 B\#9) capacitor c=65.38a
    C133 (B\#9 VSS!) capacitor c=1.38631e-18
    C173 (B\#9 7) capacitor c=10.9333f
    C54 (B\#7 CIN\#4) capacitor c=559.233a
    C134 (B\#7 VSS!) capacitor c=1.24898e-18
    C156 (B\#7 coutn) capacitor c=1.59201e-15
    C158 (coutn\#2310 B\#7) capacitor c=36.343a
    C174 (B\#7 7) capacitor c=7.86837e-15
    C57 (VSS! CIN) capacitor c=4.13856e-18
    C95 (7 CIN) capacitor c=697.246a
    C46 (B CIN) capacitor c=56.9458a
    C163 (7 B) capacitor c=2.87643e-15
    C55 (CIN\#2 B) capacitor c=659.561a
    C64 (CIN\#2 VSS!) capacitor c=10.8796a
    C104 (CIN\#2 7) capacitor c=4.49708e-15
    C87 (coutn\#8 CIN) capacitor c=56.9553a
    C326 (coutn\#8 7) capacitor c=425.318a
    C59 (CIN\#7 VSS!) capacitor c=5.14167e-18
    C73 (CIN\#7 A\#2315) capacitor c=34.5781a
    C97 (CIN\#7 7) capacitor c=1.69613e-15
    C2 (VDD!\#6 CIN\#7) capacitor c=154.601a
    C29 (VDD!\#6 net47\#2) capacitor c=107.267a
    C120 (net47\#2 CIN\#7) capacitor c=672.699a
    C358 (sumn\#5 net47\#2) capacitor c=140.258a
    C38 (VDD!\#6 X46_5) capacitor c=46.1745a
    C39 (VDD!\#6 X44_5) capacitor c=335.066a
    C126 (CIN\#7 X44_5) capacitor c=453.221a
    C398 (net47\#2 X44_5) capacitor c=315.505a
    C47 (B\#2310 CIN\#7) capacitor c=34.5781a
    C129 (B\#2310 VSS!) capacitor c=1.29138e-18
    C165 (B\#2310 7) capacitor c=2.29034e-15
    C403 (X46_5 net43) capacitor c=152.718a
    C406 (net39\#2 X46_5) capacitor c=163.003a
    C190 (B\#2314 X46_5) capacitor c=526.552a
    C128 (B\#2314 VSS!) capacitor c=14.1564a
    C143 (A\#2315 B\#2314) capacitor c=34.5781a
    C79 (CIN\#6 A\#2312) capacitor c=820.037a
    C146 (A\#2312 B\#2311) capacitor c=732.849a
    C147 (B\#9 A\#2312) capacitor c=141.536a
    C161 (sumn\#5 B\#2314) capacitor c=361.525a
    C164 (B\#2314 7) capacitor c=2.1893e-15
    C186 (B\#2314 net47) capacitor c=30.7703a
    C188 (B\#2314 net43) capacitor c=200.273a
    C189 (net39\#2 B\#2314) capacitor c=257.173a
    C204 (A\#2312 VSS!) capacitor c=13.1931a
    C291 (A\#2312 7) capacitor c=7.59932e-15
    C3 (VDD!\#7 B\#2310) capacitor c=155.241a
    C14 (VDD!\#4 coutn\#2313) capacitor c=605.918a
    C84 (CIN\#6 coutn\#2313) capacitor c=586.639a
    C217 (coutn\#2313 VSS!) capacitor c=10.8214a
    C320 (coutn\#2313 7) capacitor c=5.62205e-15
    C323 (coutn\#2311 7) capacitor c=6.30053e-15
    C20 (VDD!\#4 sumn\#9) capacitor c=24.5896a
    C24 (net38\#4 VDD!) capacitor c=407.733a
    C376 (net38\#4 7) capacitor c=3.21005e-15
    C25 (net38\#6 VDD!\#2312) capacitor c=84.6238a
    C4 (VDD!\#2312 B\#2) capacitor c=822.117a
    C131 (B\#2 VSS!) capacitor c=2.0791e-18
    C167 (B\#2 7) capacitor c=2.54178e-15
    C183 (net38\#6 B\#2) capacitor c=189.444a
    C392 (net38\#6 X35_5) capacitor c=175.027a
    C45 (VDD!\#2312 X35_5) capacitor c=136.992a
    C193 (B\#2 X35_5) capacitor c=532.503a
    C344 (coutn\#9 X35_5) capacitor c=28.8703a
    C28 (VDD!\#2312 net37\#2) capacitor c=17.9818a
    C44 (VDD!\#2312 X36_5) capacitor c=28.66a
    C119 (net37\#2 CIN\#2) capacitor c=19.2077a
    C184 (net37\#2 B) capacitor c=4.07873e-18
    C378 (net37\#2 7) capacitor c=241.597a
    C388 (net37\#2 net38\#4) capacitor c=108.479a
    C391 (net38\#4 X36_5) capacitor c=305.366a
    C394 (net37\#2 X36_5) capacitor c=152.132a
    C30 (net47\#4 VDD!\#7) capacitor c=107.267a
    C187 (net47\#4 B\#2310) capacitor c=672.699a
    C40 (VDD!\#7 X43_5) capacitor c=328.08a
    C191 (B\#2310 X43_5) capacitor c=453.221a
    C399 (net47\#4 X43_5) capacitor c=316.082a
    C353 (net47\#4 sumn) capacitor c=140.526a
    C90 (CIN\#6 sumn) capacitor c=2.67441e-15
    C159 (B\#2310 sumn) capacitor c=355.395a
    C144 (A\#2311 B\#2310) capacitor c=34.5781a
    C160 (B\#9 sumn) capacitor c=1.29328e-15
    C201 (A\#2311 VSS!) capacitor c=3.52986e-18
    C224 (sumn VSS!) capacitor c=69.5403a
    C255 (COUT\#3 sumn) capacitor c=52.8059a
    C278 (A\#2311 sumn) capacitor c=602.046a
    C284 (A\#2311 7) capacitor c=2.85675e-15
    C317 (coutn\#2313 sumn) capacitor c=759.429a
    C263 (sumn\#7 SUM\#1) capacitor c=43.2818a
    C8 (VDD!\#8 A\#2311) capacitor c=155.241a
    C33 (VDD!\#4 net47\#8) capacitor c=42.066a
    C244 (net47\#8 VSS!) capacitor c=65.8394a
    C336 (net47\#8 coutn\#2313) capacitor c=178.784a
    C355 (net47\#8 sumn) capacitor c=82.6549a
    C356 (sumn\#9 net47\#8) capacitor c=75.0251a
    C379 (net47\#8 7) capacitor c=1.00118e-15
    C31 (net47\#6 VDD!\#8) capacitor c=95.9263a
    C310 (net47\#6 A\#2311) capacitor c=651.541a
    C354 (net47\#6 sumn) capacitor c=140.526a
    C41 (VDD!\#8 X42_5) capacitor c=286.808a
    C400 (net47\#6 X42_5) capacitor c=316.082a
    C313 (A\#2311 X42_5) capacitor c=453.221a
    C80 (A\#2310 CIN\#6) capacitor c=600.107a
    C148 (A\#2310 B\#9) capacitor c=1.68368e-15
    C205 (A\#2310 VSS!) capacitor c=5.33677e-18
    C279 (sumn\#3 A\#2310) capacitor c=1.09026e-15
    C292 (A\#2310 7) capacitor c=9.02966e-15
    C365 (sumn\#9 X41_5) capacitor c=182.679a
    C401 (net47\#8 X41_5) capacitor c=172.489a
    C337 (coutn\#2313 X41_5) capacitor c=513.301a
    C155 (B\#9 coutn\#2312) capacitor c=586.485a
    C272 (A\#2310 coutn\#2312) capacitor c=600.776a
    C318 (sumn\#3 coutn\#2312) capacitor c=82.6531a
    C322 (coutn\#2312 7) capacitor c=6.34442e-15
    C60 (CIN\#3 VSS!) capacitor c=23.3263a
    C74 (CIN\#3 A\#8) capacitor c=12.2154a
    C83 (A\#6 CIN\#4) capacitor c=600.16a
    C86 (coutn\#9 CIN\#3) capacitor c=199.176a
    C98 (CIN\#3 7) capacitor c=1.59774e-15
    C117 (net38\#2 CIN\#3) capacitor c=208.864a
    C154 (A\#6 B\#7) capacitor c=619.166a
    C294 (A\#6 7) capacitor c=6.33332e-15
    C342 (coutn\#9 X38_5) capacitor c=280.21a
    C390 (net38\#2 X38_5) capacitor c=297.496a
    C127 (CIN\#3 X38_5) capacitor c=445.713a
    C118 (CIN\#3 net37) capacitor c=30.2997a
    C243 (net37 VSS!) capacitor c=2.98583e-18
    C335 (coutn\#8 net37) capacitor c=105.512a
    C377 (net37 7) capacitor c=244.097a
    C387 (net38\#4 net37) capacitor c=118.816a
    C61 (CIN\#1 VSS!) capacitor c=23.3047a
    C101 (CIN\#1 7) capacitor c=2.78243e-15
    C49 (CIN\#1 B\#6) capacitor c=10.1661a
    C170 (B\#6 7) capacitor c=2.24351e-15
    C150 (B\#7 A) capacitor c=1.12653e-15
    C76 (CIN\#1 A) capacitor c=369.548a
    C81 (CIN\#2 A) capacitor c=282.449a
    C82 (A\#2 CIN\#2) capacitor c=1.26748e-19
    C142 (A B) capacitor c=1.34857e-15
    C152 (A\#2 B) capacitor c=4.41175e-18
    C199 (A VSS!) capacitor c=27.8717a
    C282 (7 A) capacitor c=15.9583f
    C293 (A\#2 7) capacitor c=35.4849a
    C71 (SUM\#1 CIN\#2312) capacitor c=5.2202e-18
    C92 (sumn\#7 CIN\#2312) capacitor c=306.766a
    C99 (CIN\#2312 7) capacitor c=2.63008e-15
    C65 (VSS!\#1 CIN\#2312) capacitor c=75.9552a
    C198 (VSS!\#1 SUM\#1) capacitor c=109.82a
    C226 (VSS!\#1 sumn\#2312) capacitor c=187.128a
    C351 (sumn\#2312 net5) capacitor c=1.12473e-18
    C113 (CIN\#2312 net5) capacitor c=83.616a
    C114 (CIN\#6 net5) capacitor c=3.80386e-19
    C115 (CIN\#4 net5) capacitor c=1.29005e-18
    C110 (CIN\#4 net9) capacitor c=2.78347e-18
    C108 (CIN\#2312 net9) capacitor c=8.74772e-18
    C109 (CIN\#6 net9) capacitor c=8.20735e-19
    C78 (A\#2312 CIN\#5) capacitor c=370.451a
    C100 (CIN\#5 7) capacitor c=2.83119e-15
    C112 (CIN\#2311 net9) capacitor c=2.50839e-19
    C116 (CIN\#2311 net5) capacitor c=1.16256e-19
    C227 (sumn\#7 VSS!\#1) capacitor c=91.0597a
    C240 (VSS!\#1 net5) capacitor c=73.2456a
    C239 (VSS!\#2 net9) capacitor c=20.5569a
    C350 (sumn\#7 net9) capacitor c=12.4192a
    C352 (sumn\#7 net5) capacitor c=56.9465a
    C372 (net9 7) capacitor c=297.483a
    C374 (net5 7) capacitor c=367.889a
    C241 (VSS!\#2 net5\#2) capacitor c=70.6982a
    C375 (net5\#2 7) capacitor c=191.085a
    C386 (net5\#2 net9) capacitor c=50.7743a
    C48 (B\#8 CIN\#5) capacitor c=10.1661a
    C169 (B\#8 7) capacitor c=2.22092e-15
    C66 (VSS!\#8 CIN\#5) capacitor c=101.548a
    C75 (CIN\#5 A\#2314) capacitor c=10.1661a
    C287 (A\#2314 7) capacitor c=1.57078e-15
    C77 (A\#4 CIN\#1) capacitor c=10.1661a
    C290 (A\#4 7) capacitor c=1.59739e-15
    C88 (coutn\#5 CIN\#1) capacitor c=171.918a
    C276 (coutn\#5 A) capacitor c=95.7583a
    C327 (coutn\#5 7) capacitor c=679.813a
    C157 (coutn\#3 B\#6) capacitor c=673.868a
    C325 (coutn\#3 7) capacitor c=521.495a
    C106 (CIN\#1 net3) capacitor c=169.552a
    C295 (net3 A) capacitor c=11.302a
    C329 (coutn\#5 net3) capacitor c=50.7743a
    C220 (VSS!\#2316 coutn\#5) capacitor c=11.228a
    C211 (VSS!\#2316 A) capacitor c=352.557a
    C212 (VSS!\#2316 A\#4) capacitor c=424.978a
    C214 (A\#2 VSS!\#2316) capacitor c=1.39404e-18
    C366 (net3 7) capacitor c=608.617a
    C107 (CIN\#5 net20) capacitor c=596.183a
    C234 (VSS!\#8 net20) capacitor c=56.6133a
    C300 (A\#2314 net20) capacitor c=6.92484e-18
    C301 (A\#2312 net20) capacitor c=173.205a
    C393 (X37_5 net37) capacitor c=162.993a
    C153 (A\#2 B\#3) capacitor c=1.03969e-20
    C136 (VSS!\#2314 B) capacitor c=20.943a
    C181 (net5\#2 B\#2313) capacitor c=118.603a
    C192 (B\#1 X36_5) capacitor c=520.736a
    C316 (A\#1 X36_5) capacitor c=514.402a
    C297 (net3\#2 A\#4) capacitor c=194.008a
    C141 (B\#9 COUT) capacitor c=1.04443e-15
    C149 (A\#5 B\#9) capacitor c=86.324a
    C305 (net9\#2 A\#2312) capacitor c=20.7311a
    C275 (coutn\#8 A\#1) capacitor c=176.814a
    C343 (coutn\#8 X37_5) capacitor c=153.954a
    C286 (A\#1 7) capacitor c=4.16715e-15
    C315 (A\#1 X37_5) capacitor c=531.108a
    C247 (X37_5 VSS!) capacitor c=5.72996e-18
    C203 (A\#1 VSS!) capacitor c=33.3074a
    C130 (B\#1 VSS!) capacitor c=9.03878e-18
    C166 (B\#1 7) capacitor c=617.622a
    C138 (B\#3 VSS!) capacitor c=15.2621a
    C175 (B\#3 7) capacitor c=6.27214e-15
    C151 (B\#3 A) capacitor c=2.89232e-18
    C168 (B\#2313 7) capacitor c=2.29102e-15
    C139 (VSS!\#2 B\#2313) capacitor c=25.7499a
    C145 (A\#2314 B\#2313) capacitor c=10.1661a
    C171 (B\#4 7) capacitor c=2.16339e-15
    C137 (VSS!\#2314 B\#4) capacitor c=808.681a
    C213 (VSS!\#2314 A) capacitor c=35.2518a
    C176 (net3\#4 B\#4) capacitor c=114.863a
    C231 (net3\#4 VSS!) capacitor c=482.018a
    C368 (net3\#4 7) capacitor c=655.91a
    C179 (B\#2313 net9) capacitor c=637.96a
    C304 (net9\#2 A\#2314) capacitor c=137.701a
    C373 (net9\#2 7) capacitor c=686.593a
    C182 (net38\#4 B\#1) capacitor c=222.441a
    C307 (net38\#4 A\#1) capacitor c=9.33658e-18
    C185 (net37\#2 B\#1) capacitor c=184.529a
    C308 (net37\#2 A\#1) capacitor c=380.316a
    C206 (VSS!\#7 A\#2314) capacitor c=103.456a
    C238 (net9\#2 VSS!\#7) capacitor c=47.9632a
    C222 (VSS!\#4 coutn\#2312) capacitor c=560.728a
    C229 (VSS!\#6 7) capacitor c=77.1502f
    C237 (net20\#6 VSS!) capacitor c=4.25977e-18
    C332 (net20\#6 coutn\#2312) capacitor c=87.2733a
    C140 (VSS!\#6 B\#6) capacitor c=23.7445a
    C177 (net1\#2 B\#6) capacitor c=114.863a
    C233 (VSS!\#6 net1\#2) capacitor c=98.6147a
    C331 (coutn\#3 net1\#2) capacitor c=170.439a
    C370 (net1\#2 7) capacitor c=599.282a
    C196 (VSS!\#6 COUT) capacitor c=502.591a
    C249 (coutn\#2312 COUT) capacitor c=658.87a
    C254 (sumn\#3 COUT) capacitor c=210.915a
    C256 (7 COUT) capacitor c=21.2826f
    C259 (net20\#6 COUT) capacitor c=129.82a
    C349 (net20\#6 sumn\#3) capacitor c=41.9258a
    C280 (sumn\#3 A\#5) capacitor c=14.25a
    C248 (A\#5 COUT) capacitor c=1.15204e-15
    C274 (coutn\#3 A\#5) capacitor c=1.17461e-15
    C219 (coutn\#3 VSS!\#2313) capacitor c=65.9764a
    C210 (VSS!\#2313 A\#5) capacitor c=115.902a
    C296 (net3\#2 A) capacitor c=8.77126e-18
    C230 (VSS!\#2316 net3\#2) capacitor c=90.5588a
    C367 (net3\#2 7) capacitor c=1.2568e-15
    C384 (net1\#2 net3) capacitor c=10.5723a
    C232 (VSS!\#6 net1) capacitor c=160.089a
    C299 (A\#5 net1) capacitor c=5.69523e-18
    C369 (net1 7) capacitor c=613.293a
    C208 (VSS!\#2311 A\#5) capacitor c=92.5414a
    C195 (COUT\#4 VSS!\#2311) capacitor c=115.006a
    C223 (VSS!\#6 coutn\#2311) capacitor c=1.14084e-15
    C250 (coutn\#2311 COUT) capacitor c=341.926a
    C258 (COUT\#4 7) capacitor c=568.376a
    C273 (A\#5 coutn\#2311) capacitor c=582.645a
    C330 (coutn\#2311 net1) capacitor c=3.09607e-18
    C135 (VSS!\#9 B\#8) capacitor c=112.091a
    C178 (net20\#2 B\#8) capacitor c=627.49a
    C235 (VSS!\#9 net20\#2) capacitor c=75.3037a
    C385 (net9\#2 net20) capacitor c=10.9269a
    C236 (VSS!\#2310 net20\#4) capacitor c=72.3442a
    C371 (net20\#4 7) capacitor c=2.89926e-15
    C207 (VSS!\#2310 A\#9) capacitor c=110.005a
    C288 (A\#9 7) capacitor c=1.65993e-15
    C289 (A\#7 7) capacitor c=1.83477e-15
    C209 (VSS!\#2313 A\#7) capacitor c=524.659a
    C298 (A\#7 net1) capacitor c=117.579a
    C215 (A\#6 VSS!\#2313) capacitor c=172.89a
    C302 (net20\#4 A\#9) capacitor c=416.514a
    C303 (net20\#4 A\#2310) capacitor c=541.912a
    MX34_M0_unmatched (SUM\#1 sumn\#2312 VSS!\#1 VSS!\#1) nch w=2e-06 \
        l=1e-06 as=0 ad=5e-12 ps=0 pd=9e-06 sa=2e-06 sb=2e-06
    MX33_M0_unmatched (sumn\#7 CIN\#2312 net5 net5) nch w=2e-06 l=1e-06 \
        as=0 ad=5e-12 ps=0 pd=9e-06 sa=2e-06 sb=2e-06
    MX23_M0_unmatched (coutn\#5 CIN\#1 net3 net3) nch w=2e-06 l=1e-06 as=0 \
        ad=5e-12 ps=0 pd=9e-06 sa=2e-06 sb=2e-06
    MX30_M0_unmatched (net20 CIN\#5 VSS!\#8 VSS!\#8) nch w=2e-06 l=1e-06 \
        as=0 ad=5e-12 ps=0 pd=9e-06 sa=2e-06 sb=2e-06
    MX32_M0_unmatched (net5\#2 B\#2313 net9 net9) nch w=2e-06 l=1e-06 as=0 \
        ad=5e-12 ps=0 pd=9e-06 sa=2e-06 sb=2e-06
    MX22_M0_unmatched (net3\#2 A\#4 VSS!\#2316 VSS!\#2316) nch w=2e-06 \
        l=1e-06 as=0 ad=5e-12 ps=0 pd=9e-06 sa=2e-06 sb=2e-06
    MX21_M0_unmatched (net3\#4 B\#4 VSS!\#2314 VSS!\#2314) nch w=2e-06 \
        l=1e-06 as=0 ad=5e-12 ps=0 pd=9e-06 sa=2e-06 sb=2e-06
    MX31_M0_unmatched (net9\#2 A\#2314 VSS!\#7 VSS!\#7) nch w=2e-06 \
        l=1e-06 as=0 ad=5e-12 ps=0 pd=9e-06 sa=2e-06 sb=2e-06
    MX24_M0_unmatched (coutn\#3 B\#6 net1\#2 net1\#2) nch w=2e-06 l=1e-06 \
        as=0 ad=5e-12 ps=0 pd=9e-06 sa=2e-06 sb=2e-06
    MX27_M0_unmatched (sumn\#3 coutn\#2312 net20\#6 net20\#6) nch w=2e-06 \
        l=1e-06 as=0 ad=5e-12 ps=0 pd=9e-06 sa=2e-06 sb=2e-06
    MX26_M0_unmatched (COUT\#4 coutn\#2311 VSS!\#2311 VSS!\#2311) nch \
        w=2e-06 l=1e-06 as=0 ad=5e-12 ps=0 pd=9e-06 sa=2e-06 sb=2e-06
    MX29_M0_unmatched (net20\#2 B\#8 VSS!\#9 VSS!\#9) nch w=2e-06 l=1e-06 \
        as=0 ad=5e-12 ps=0 pd=9e-06 sa=2e-06 sb=2e-06
    MX28_M0_unmatched (net20\#4 A\#9 VSS!\#2310 VSS!\#2310) nch w=2e-06 \
        l=1e-06 as=0 ad=5e-12 ps=0 pd=9e-06 sa=2e-06 sb=2e-06
    MX25_M0_unmatched (net1 A\#7 VSS!\#2313 VSS!\#2313) nch w=2e-06 \
        l=1e-06 as=0 ad=5e-12 ps=0 pd=9e-06 sa=2e-06 sb=2e-06
    MX48_M0_unmatched (SUM\#2 sumn\#2310 VDD!\#1 VDD!\#1) pch w=4e-06 \
        l=1e-06 as=0 ad=1e-11 ps=0 pd=1.3e-05 sa=2e-06 sb=2e-06
    MX40_M0_unmatched (COUT\#3 coutn\#2314 VDD!\#9 VDD!\#9) pch w=4e-06 \
        l=1e-06 as=0 ad=1e-11 ps=0 pd=1.3e-05 sa=2e-06 sb=2e-06
    MX39_M0_unmatched (net38 A\#8 VDD!\#2311 VDD!\#2311) pch w=4e-06 \
        l=1e-06 as=0 ad=1e-11 ps=0 pd=1.3e-05 sa=2e-06 sb=2e-06
    MX47_M0_unmatched (sumn\#8 CIN\#2310 net39 net39) pch w=4e-06 l=1e-06 \
        as=0 ad=1e-11 ps=0 pd=1.3e-05 sa=2e-06 sb=2e-06
    MX45_M0_unmatched (net43\#2 A\#2315 net47 net47) pch w=4e-06 l=1e-06 \
        as=0 ad=1e-11 ps=0 pd=1.3e-05 sa=2e-06 sb=2e-06
    MX44_M0_unmatched (net47\#2 CIN\#7 VDD!\#6 VDD!\#6) pch w=4e-06 \
        l=1e-06 as=0 ad=1e-11 ps=0 pd=1.3e-05 sa=2e-06 sb=2e-06
    MX46_M0_unmatched (net39\#2 B\#2314 net43 net43) pch w=4e-06 l=1e-06 \
        as=0 ad=1e-11 ps=0 pd=1.3e-05 sa=2e-06 sb=2e-06
    MX35_M0_unmatched (net38\#6 B\#2 VDD!\#2312 VDD!\#2312) pch w=4e-06 \
        l=1e-06 as=0 ad=1e-11 ps=0 pd=1.3e-05 sa=2e-06 sb=2e-06
    MX43_M0_unmatched (net47\#4 B\#2310 VDD!\#7 VDD!\#7) pch w=4e-06 \
        l=1e-06 as=0 ad=1e-11 ps=0 pd=1.3e-05 sa=2e-06 sb=2e-06
    MX42_M0_unmatched (net47\#6 A\#2311 VDD!\#8 VDD!\#8) pch w=4e-06 \
        l=1e-06 as=0 ad=1e-11 ps=0 pd=1.3e-05 sa=2e-06 sb=2e-06
    MX41_M0_unmatched (sumn\#9 coutn\#2313 net47\#8 net47\#8) pch w=4e-06 \
        l=1e-06 as=0 ad=1e-11 ps=0 pd=1.3e-05 sa=2e-06 sb=2e-06
    MX38_M0_unmatched (coutn\#9 CIN\#3 net38\#2 net38\#2) pch w=4e-06 \
        l=1e-06 as=0 ad=1e-11 ps=0 pd=1.3e-05 sa=2e-06 sb=2e-06
    MX37_M0_unmatched (coutn\#8 A\#1 net37 net37) pch w=4e-06 l=1e-06 as=0 \
        ad=1e-11 ps=0 pd=1.3e-05 sa=2e-06 sb=2e-06
    MX36_M0_unmatched (net37\#2 B\#1 net38\#4 net38\#4) pch w=4e-06 \
        l=1e-06 as=0 ad=1e-11 ps=0 pd=1.3e-05 sa=2e-06 sb=2e-06
ends ADDFX1_analog_extracted
// End of subcircuit definition.

// Library name: KISTA_SOI_STDLIB2
// Cell name: ADDHX1
// View name: analog_extracted
subckt ADDHX1_analog_extracted A B COUT SUM
    C28 (sumn\#7 VSS!) capacitor c=1.24288e-19
    C45 (VDD!\#1 SUM\#2) capacitor c=100.498a
    C50 (SUM\#2 sumn\#7) capacitor c=257.19a
    C53 (SUM\#2 5) capacitor c=1.33433e-15
    C106 (VDD!\#1 sumn\#7) capacitor c=185.584a
    C155 (sumn\#7 5) capacitor c=1.29227e-15
    C1 (SUM VSS!) capacitor c=8.97863e-18
    C52 (5 SUM) capacitor c=2.02246e-15
    C3 (A VSS!) capacitor c=31.2988a
    C70 (5 A) capacitor c=5.18134e-15
    C4 (A\#2 VSS!) capacitor c=33.1478a
    C71 (A\#2 5) capacitor c=8.83269e-15
    C5 (A\#3 VSS!) capacitor c=3.61751e-18
    C72 (A\#3 5) capacitor c=7.17354e-15
    C9 (COUT\#2 VSS!) capacitor c=12.8329a
    C97 (COUT\#2 5) capacitor c=846.906a
    C11 (VDD!\#7 VSS!) capacitor c=37.9392a
    C12 (VDD!\#9 VSS!) capacitor c=35.6553a
    C81 (COUT\#2 VDD!\#9) capacitor c=100.523a
    C13 (B VSS!) capacitor c=10.5982a
    C59 (B A) capacitor c=49.0044a
    C126 (5 B) capacitor c=4.87473e-15
    C14 (B\#2 VSS!) capacitor c=10.3717a
    C47 (SUM\#2 B\#2) capacitor c=5.32707e-18
    C127 (B\#2 5) capacitor c=2.62843e-15
    C15 (B\#6 VSS!) capacitor c=17.3624a
    C60 (A\#3 B\#6) capacitor c=11.8106a
    C83 (COUT\#2 B\#6) capacitor c=4.13828e-18
    C128 (B\#6 5) capacitor c=1.9637e-15
    C16 (B\#5 VSS!) capacitor c=5.28289e-19
    C131 (B\#5 5) capacitor c=266.089a
    C19 (coutn VSS!) capacitor c=38.4778a
    C87 (COUT\#2 coutn) capacitor c=157.097a
    C142 (5 coutn) capacitor c=10.094f
    C20 (coutn\#2310 VSS!) capacitor c=13.2193a
    C64 (coutn\#2310 A\#2) capacitor c=25.354a
    C88 (COUT\#2 coutn\#2310) capacitor c=5.79089e-18
    C143 (coutn\#2310 5) capacitor c=3.8921e-15
    C21 (coutn\#2311 VSS!) capacitor c=17.3797a
    C89 (COUT\#2 coutn\#2311) capacitor c=175.573a
    C103 (VDD!\#9 coutn\#2311) capacitor c=225.73a
    C144 (coutn\#2311 5) capacitor c=1.50921e-15
    C22 (coutn\#9 VSS!) capacitor c=40.4671a
    C145 (coutn\#9 5) capacitor c=4.27485e-15
    C24 (coutn\#3 VSS!) capacitor c=7.81798e-18
    C120 (coutn\#3 B\#6) capacitor c=332.936a
    C26 (coutn\#5 VSS!) capacitor c=2.71445e-18
    C65 (coutn\#5 A\#3) capacitor c=175.25a
    C27 (coutn\#2 VSS!) capacitor c=9.03853e-18
    C66 (coutn\#2 A) capacitor c=29.9058a
    C122 (coutn\#2 B) capacitor c=864.951a
    C123 (B\#5 coutn\#2) capacitor c=54.8227a
    C31 (sumn\#5 VSS!) capacitor c=4.51507e-18
    C107 (sumn\#5 VDD!\#1) capacitor c=78.403a
    C124 (sumn\#5 B\#2) capacitor c=382.386a
    C32 (sumn\#6 VSS!) capacitor c=5.76875e-18
    C68 (sumn\#6 A\#2) capacitor c=12.288a
    C93 (COUT\#2 sumn\#6) capacitor c=79.8109a
    C140 (sumn\#6 coutn\#2310) capacitor c=451.668a
    C33 (sumn\#4 VSS!) capacitor c=28.5509a
    C34 (sumn\#3 VSS!) capacitor c=32.5267a
    C141 (sumn\#3 coutn\#9) capacitor c=806.331a
    C157 (sumn\#3 5) capacitor c=13.1515f
    C35 (sumn\#3 VSS!\#6) capacitor c=12.2283a
    C36 (VSS!\#2 5) capacitor c=38.1865f
    C17 (VSS!\#2 B\#3) capacitor c=1.17329e-15
    C46 (B\#3 SUM) capacitor c=3.12071e-18
    C125 (sumn\#3 B\#3) capacitor c=590.881a
    C129 (B\#3 5) capacitor c=8.72508e-15
    C37 (net7 VSS!) capacitor c=12.0486a
    C132 (net7 B) capacitor c=66.3488a
    C135 (B\#5 net7) capacitor c=4.78679e-18
    C167 (net7 5) capacitor c=237.155a
    C39 (VSS!\#6 net2) capacitor c=72.4449a
    C136 (B\#3 net2) capacitor c=267.554a
    C169 (net2 5) capacitor c=456.754a
    C41 (VSS!\#2 net2\#3) capacitor c=40.5697a
    C149 (net2\#3 coutn\#9) capacitor c=213.64a
    C158 (net2\#3 sumn\#4) capacitor c=86.4992a
    C171 (net2\#3 5) capacitor c=1.19154e-15
    C159 (sumn\#3 net2\#4) capacitor c=322.585a
    C170 (net2\#4 5) capacitor c=2.17218e-15
    C94 (COUT\#1 sumn\#4) capacitor c=49.5333a
    C90 (COUT\#1 coutn) capacitor c=25.8805a
    C91 (COUT\#1 coutn\#9) capacitor c=7.01886e-18
    C98 (COUT\#1 5) capacitor c=712.119a
    C10 (COUT\#1 VSS!\#8) capacitor c=69.87a
    C23 (VSS!\#8 coutn\#8) capacitor c=196.519a
    C92 (COUT\#1 coutn\#8) capacitor c=222.7a
    C146 (coutn\#8 5) capacitor c=2.74979e-15
    C147 (coutn\#8 net7) capacitor c=1.12473e-18
    C119 (B\#4 coutn\#9) capacitor c=15.7266a
    C84 (COUT\#1 B\#4) capacitor c=9.5086e-18
    C130 (B\#4 5) capacitor c=6.85966e-15
    C133 (B\#4 net7) capacitor c=83.616a
    C61 (A\#5 B\#3) capacitor c=11.3921a
    C69 (sumn\#3 A\#5) capacitor c=591.8a
    C73 (A\#5 5) capacitor c=2.89776e-15
    C77 (net2\#4 A\#5) capacitor c=634.673a
    C85 (B\#5 COUT) capacitor c=1.59299e-19
    C82 (B COUT) capacitor c=2.51329e-18
    C86 (coutn COUT) capacitor c=312.421a
    C95 (sumn\#3 COUT) capacitor c=105.529a
    C96 (5 COUT) capacitor c=1.64018e-15
    C99 (COUT\#2 X13_5) capacitor c=182.808a
    C116 (VDD!\#9 X13_5) capacitor c=177.83a
    C151 (X13_5 coutn) capacitor c=289.608a
    C152 (coutn\#2311 X13_5) capacitor c=244.067a
    C44 (VSS!\#4 X13_5) capacitor c=45.5491a
    C18 (VSS!\#4 B\#4) capacitor c=953.884a
    C25 (coutn\#6 VSS!\#8) capacitor c=51.6956a
    C121 (coutn\#6 B\#4) capacitor c=112.206a
    C148 (coutn\#6 net7) capacitor c=46.0379a
    C67 (A\#4 coutn\#2) capacitor c=1.8955e-18
    C63 (A\#4 B) capacitor c=3.10601e-18
    C75 (A\#4 5) capacitor c=284.497a
    C134 (net7\#2 B) capacitor c=58.106a
    C62 (A\#6 B) capacitor c=52.1451a
    C74 (A\#6 5) capacitor c=1.4584e-15
    C76 (net7\#2 A\#6) capacitor c=83.616a
    C168 (net7\#2 5) capacitor c=237.352a
    C56 (VDD!\#6 A) capacitor c=20.8062a
    C105 (coutn\#5 VDD!\#6) capacitor c=95.4586a
    C8 (A\#4 VSS!\#5) capacitor c=1.2791e-18
    C7 (VSS!\#5 A\#6) capacitor c=134.209a
    C38 (VSS!\#5 net7\#2) capacitor c=58.0934a
    C42 (net6\#2 VSS!) capacitor c=1.87456e-18
    C78 (net6\#2 A\#2) capacitor c=139.36a
    C111 (VDD!\#7 net6\#2) capacitor c=97.7059a
    C162 (sumn\#3 net6\#2) capacitor c=11.0426a
    C173 (net6\#2 5) capacitor c=82.2899a
    C154 (coutn\#5 X11_5) capacitor c=326.868a
    C80 (A\#3 X11_5) capacitor c=504.33a
    C118 (VDD!\#6 X11_5) capacitor c=448.721a
    C58 (VDD!\#5 A\#3) capacitor c=1.69221e-15
    C57 (VDD!\#3 A\#2) capacitor c=1.62499e-15
    C79 (A\#2 X15_5) capacitor c=505.193a
    C101 (VDD!\#3 B\#2) capacitor c=11.0323a
    C109 (VDD!\#3 sumn\#6) capacitor c=15.3951a
    C110 (VDD!\#3 5) capacitor c=37.2069f
    C114 (VDD!\#7 X15_5) capacitor c=183.145a
    C165 (sumn\#3 X15_5) capacitor c=21.6005a
    C175 (net6\#2 X15_5) capacitor c=330.814a
    C48 (sumn SUM) capacitor c=257.014a
    C49 (SUM\#2 sumn) capacitor c=104.549a
    C55 (SUM\#2 X17_5) capacitor c=406.72a
    C54 (SUM\#1 5) capacitor c=550.044a
    C112 (VDD!\#3 net6) capacitor c=14.8334a
    C113 (VDD!\#1 X17_5) capacitor c=216.078a
    C163 (sumn\#7 X17_5) capacitor c=508.173a
    C137 (B\#2 net6) capacitor c=139.36a
    C160 (sumn\#7 net6) capacitor c=1.87456e-18
    C161 (sumn\#5 net6) capacitor c=82.8682a
    C172 (net6 5) capacitor c=81.8764a
    C156 (sumn\#9 5) capacitor c=1.47098e-15
    C51 (SUM\#1 sumn\#9) capacitor c=171.455a
    C100 (VDD!\#2310 B\#6) capacitor c=158.851a
    C102 (VDD!\#8 coutn\#2310) capacitor c=239.434a
    C104 (VDD!\#2310 coutn\#3) capacitor c=120.295a
    C108 (VDD!\#8 sumn\#6) capacitor c=96.4516a
    C29 (VSS!\#1 sumn) capacitor c=17.485a
    C2 (VSS!\#1 SUM\#1) capacitor c=69.5598a
    C30 (VSS!\#1 sumn\#9) capacitor c=137.302a
    C6 (VSS!\#7 A\#5) capacitor c=134.247a
    C40 (net2\#4 VSS!\#7) capacitor c=129.078a
    C43 (VSS!\#4 X14_5) capacitor c=45.5492a
    C115 (VDD!\#8 X14_5) capacitor c=177.83a
    C150 (coutn\#2310 X14_5) capacitor c=504.608a
    C166 (sumn\#6 X14_5) capacitor c=205.061a
    C138 (B\#2 X16_5) capacitor c=550.286a
    C164 (sumn\#5 X16_5) capacitor c=189.822a
    C174 (X16_5 net6) capacitor c=330.814a
    C117 (VDD!\#2310 X12_5) capacitor c=182.825a
    C139 (B\#6 X12_5) capacitor c=535.301a
    C153 (coutn\#3 X12_5) capacitor c=531.172a
    MX17_M0_unmatched (SUM\#2 sumn\#7 VDD!\#1 VDD!\#1) pch w=4e-06 l=1e-06 \
        as=0 ad=1e-11 ps=0 pd=1.3e-05 sa=2e-06 sb=2e-06
    MX13_M0_unmatched (COUT\#2 coutn\#2311 VDD!\#9 VDD!\#9) pch w=4e-06 \
        l=1e-06 as=0 ad=1e-11 ps=0 pd=1.3e-05 sa=2e-06 sb=2e-06
    MX15_M0_unmatched (net6\#2 A\#2 VDD!\#7 VDD!\#7) pch w=4e-06 l=1e-06 \
        as=0 ad=1e-11 ps=0 pd=1.3e-05 sa=2e-06 sb=2e-06
    MX11_M0_unmatched (coutn\#5 A\#3 VDD!\#6 VDD!\#6) pch w=4e-06 l=1e-06 \
        as=0 ad=1e-11 ps=0 pd=1.3e-05 sa=2e-06 sb=2e-06
    MX14_M0_unmatched (sumn\#6 coutn\#2310 VDD!\#8 VDD!\#8) pch w=4e-06 \
        l=1e-06 as=0 ad=1e-11 ps=0 pd=1.3e-05 sa=2e-06 sb=2e-06
    MX16_M0_unmatched (sumn\#5 B\#2 net6 net6) pch w=4e-06 l=1e-06 as=0 \
        ad=1e-11 ps=0 pd=1.3e-05 sa=2e-06 sb=2e-06
    MX12_M0_unmatched (coutn\#3 B\#6 VDD!\#2310 VDD!\#2310) pch w=4e-06 \
        l=1e-06 as=0 ad=1e-11 ps=0 pd=1.3e-05 sa=2e-06 sb=2e-06
    Rd19 (coutn\#2312 coutn\#7) resistor r=736.0318
    Rd20 (coutn\#2311 coutn\#2312) resistor r=600
    Rc26 (VDD! VDD!\#6) resistor r=2.7222
    Rc36 (VDD! VDD!\#5) resistor r=99.67m
    Rs1 (5 VSS!) resistor r=50
    Rc21 (SUM SUM\#2) resistor r=2.875
    Rd5 (A\#2 A\#3) resistor r=6017.6182
    Rd12 (VDD!\#1 VDD!\#7) resistor r=244.1221
    Rd2 (B\#5 B\#6) resistor r=1936.0317
    Rc5 (B\#5 B) resistor r=85.564
    Rc22 (coutn\#2310 coutn\#2311) resistor r=1517.6188
    Rd18 (coutn\#2310 coutn\#9) resistor r=2400
    Rd9 (coutn\#3 coutn\#5) resistor r=23.2112
    Rd8 (coutn coutn\#2) resistor r=5.0981
    Rd11 (coutn\#2 coutn\#3) resistor r=3.1952
    Rc24 (coutn\#2 coutn\#5) resistor r=3.2591
    Rc16 (sumn\#5 sumn\#3) resistor r=3.4902
    Rc2 (sumn\#3 sumn\#6) resistor r=2.7731
    Rc11 (sumn\#3 sumn\#4) resistor r=5.1981
    Rc38 (VSS!\#2 VSS!\#6) resistor r=5.1974
    Rc8 (B\#2 B\#3) resistor r=2400
    Rc27 (net2 net2\#3) resistor r=15.8283
    Rd1 (net2 net2\#4) resistor r=15.2388
    Rd7 (net2\#4 net2\#3) resistor r=15.5332
    Rc28 (coutn\#9 coutn\#8) resistor r=1517.6188
    Rd6 (B\#3 B\#4) resistor r=6017.6182
    Rc4 (A\#2 A\#5) resistor r=2400
    Rc6 (B\#4 B\#5) resistor r=436.0318
    Rc10 (COUT COUT\#2) resistor r=2.775
    Rc9 (COUT COUT\#1) resistor r=5.2
    Rc29 (coutn\#8 coutn\#7) resistor r=1036.0317
    Rc23 (coutn\#7 coutn) resistor r=80.464
    Rc33 (VSS! VSS!\#4) resistor r=0.133
    Rc35 (VSS!\#2 VSS!\#4) resistor r=234.5m
    Rc34 (VSS!\#4 VSS!\#8) resistor r=5.1974
    Rc30 (coutn\#2 coutn\#6) resistor r=5.1795
    Rc3 (net7 net7\#2) resistor r=10.1
    Rd4 (A\#3 A\#4) resistor r=1336.0317
    Rd3 (A\#4 A) resistor r=85.564
    Rc7 (A\#4 A\#6) resistor r=1036.0317
    Rc37 (VSS! VSS!\#5) resistor r=5.1972
    Rc32 (VDD!\#9 VDD!\#5) resistor r=3.6505
    Rd13 (VDD!\#3 VDD!\#9) resistor r=11.0989
    Rc31 (VDD!\#7 VDD!\#3) resistor r=2.7861
    Rc14 (net6 net6\#2) resistor r=5.05
    Rc1 (sumn sumn\#3) resistor r=6.4597
    Rc20 (SUM SUM\#1) resistor r=5.1
    Rd10 (VDD!\#1 VDD!\#3) resistor r=2.9299
    Rc15 (sumn\#7 sumn\#8) resistor r=1336.0317
    Rd14 (VDD!\#3 VDD!\#5) resistor r=133.2m
    Rd17 (VDD!\#5 VDD!\#2310) resistor r=2.7224
    Rc25 (VDD!\#3 VDD!\#8) resistor r=2.7224
    Rc18 (sumn\#8 sumn\#9) resistor r=1036.0317
    Rc19 (sumn\#8 sumn) resistor r=80.464
    Rc17 (sumn sumn\#5) resistor r=37.2538
    Rd15 (VSS!\#1 VSS!\#2) resistor r=5.2378
    Rd16 (VSS!\#2 VSS!\#7) resistor r=9.1883
    Rc39 (VSS!\#7 VSS!\#4) resistor r=12.2714
    MX9_M0_unmatched (net2 B\#3 VSS!\#6 VSS!\#6) nch w=2e-06 l=1e-06 as=0 \
        ad=5e-12 ps=0 pd=9e-06 sa=2e-06 sb=2e-06
    MX7_M0_unmatched (sumn\#4 coutn\#9 net2\#3 net2\#3) nch w=2e-06 \
        l=1e-06 as=0 ad=5e-12 ps=0 pd=9e-06 sa=2e-06 sb=2e-06
    MX6_M0_unmatched (COUT\#1 coutn\#8 VSS!\#8 VSS!\#8) nch w=2e-06 \
        l=1e-06 as=0 ad=5e-12 ps=0 pd=9e-06 sa=2e-06 sb=2e-06
    MX5_M0_unmatched (coutn\#6 B\#4 net7 net7) nch w=2e-06 l=1e-06 as=0 \
        ad=5e-12 ps=0 pd=9e-06 sa=2e-06 sb=2e-06
    MX4_M0_unmatched (net7\#2 A\#6 VSS!\#5 VSS!\#5) nch w=2e-06 l=1e-06 \
        as=0 ad=5e-12 ps=0 pd=9e-06 sa=2e-06 sb=2e-06
    MX10_M0_unmatched (SUM\#1 sumn\#9 VSS!\#1 VSS!\#1) nch w=2e-06 l=1e-06 \
        as=0 ad=5e-12 ps=0 pd=9e-06 sa=2e-06 sb=2e-06
    MX8_M0_unmatched (net2\#4 A\#5 VSS!\#7 VSS!\#7) nch w=2e-06 l=1e-06 \
        as=0 ad=5e-12 ps=0 pd=9e-06 sa=2e-06 sb=2e-06
ends ADDHX1_analog_extracted
// End of subcircuit definition.

// Library name: KISTA_SOI_STDLIB2
// Cell name: timing
// View name: schematic
I0 (net4 net3 net1 net2) AOI21X1_analog_extracted
I1 (net5 net6) BUFX2_analog_extracted
I2 (net10 net7 net12 net8 net11 net9) DFFSRX1_analog_extracted
I3 (net16 net15 net13 net14) DFFX1_analog_extracted
I4 (net17 net18) INVX1_analog_extracted
I5 (net19 net20 net21) NAND2X1_analog_extracted
I6 (net22 net23 net24) NOR2X1_analog_extracted
I7 (net27 net26 net28 net25) OAI21X1_analog_extracted
I8 (net29 net30 net31) XNOR2X1_analog_extracted
I9 (net32) TIEHI_analog_extracted
I10 (net33) TIELO_analog_extracted
I11 (net035 net034) BUFX3_analog_extracted
I12 (net036 net037) BUFX4_analog_extracted
I13 (net038 net039) BUFX8_analog_extracted
I14 (net040 net041) BUFX9_analog_extracted
I15 (net042 net043) BUFX16_analog_extracted
I16 (net044 net045) BUFX27_analog_extracted
I17 (net046 net047) BUFX32_analog_extracted
I18 (net051 net052 net048 net050 net049) DFFRX1_analog_extracted
I19 (net056 net057 net053 net054 net055) DFFSX1_analog_extracted
I20 (net058 net059) INVX2_analog_extracted
I21 (net060 net061) INVX3_analog_extracted
I22 (net062 net063) INVX4_analog_extracted
I23 (net065 net064 net066) NAND2X2_analog_extracted
I24 (net067 net068 net069) NAND2X3_analog_extracted
I26 (net070 net073 net071 net072) NAND3X1_analog_extracted
I27 (net078 net075 net074 net076 net077) NAND4X1_analog_extracted
I28 (net079 net080 net082 net081) MX2X1_analog_extracted
I29 (net087 net083 net085 net084 net088 net086 net089) \
        MX4X1_analog_extracted
I30 (net090 net091 net092) NOR2X2_analog_extracted
I31 (net094 net093 net095) NOR2X3_analog_extracted
I32 (net099 net097 net096 net098) NOR3X1_analog_extracted
I33 (net0103 net0104 net0100 net0101 net0102) NOR4X1_analog_extracted
I34 (net0106 net0105 net0107) XOR2X1_analog_extracted
I35 (net0109 net0110 net0108) AND2X1_analog_extracted
I36 (net0112 net0113 net0114 net0111) AND3X1_analog_extracted
I37 (net0117 net0118 net0119 net0116 net0115) AND4X1_analog_extracted
I38 (net0121 net0122 net0120) OR2X1_analog_extracted
I39 (net0124 net0125 net0126 net0123) OR3X1_analog_extracted
I40 (net0128 net0129 net0130 net0131 net0127) OR4X1_analog_extracted
I41 (net0135 net0132 net0134 net0133) AO21X1_analog_extracted
I42 (net0139 net0138 net0136 net0137) OA21X1_analog_extracted
I43 (net0143 net0140 net0142 net0141 net0144) ADDFX1_analog_extracted
I44 (net0147 net0148 net0145 net0146) ADDHX1_analog_extracted
simulatorOptions options psfversion="1.1.0" reltol=1e-3 vabstol=1e-6 \
    iabstol=1e-12 temp=27 tnom=27 scalem=1.0 scale=1.0 gmin=1e-12 rforce=1 \
    maxnotes=5 maxwarns=5 digits=5 cols=80 pivrel=1e-3 \
    sensfile="../psf/sens.output" checklimitdest=psf
modelParameter info what=models where=rawfile
element info what=inst where=rawfile
outputParameter info what=output where=rawfile
designParamVals info what=parameters where=rawfile
primitives info what=primitives where=rawfile
subckts info what=subckts where=rawfile
saveOptions options save=allpub
