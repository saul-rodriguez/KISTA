// Design: KISTA_SOI_STDLIB/timing
simulator lang=spectre
global 0 vss vdd

// KISTA_SOI_STDLIB/INVX1/schematic
subckt INVX1 Y A vdd vss
    M0 (Y A vss vss) nch w=2u l=1u wf=2
    M1 (Y A vdd vdd) pch w=4u l=1u
ends INVX1

// KISTA_SOI_STDLIB/NOR2X1/schematic
subckt NOR2X1 Y A B vss vdd
    M1 (net9 A vdd vdd) pch w=4u l=1u
    M0 (Y B net9 net9) pch w=4u l=1u
    M3 (Y A vss vss) nch w=2u l=1u wf=2
    M2 (Y B vss vss) nch w=2u l=1u wf=2
ends NOR2X1

// KISTA_SOI_STDLIB/BUFX2/schematic
subckt BUFX2 Y A vdd vss
    M1 (Y net6 vss vss) nch w=4u l=1u wf=4.000
    M0 (net6 A vss vss) nch w=2u l=1u wf=2
    M3 (Y net6 vdd vdd) pch w=8u l=1u
    M2 (net6 A vdd vdd) pch w=4u l=1u
ends BUFX2

// KISTA_SOI_STDLIB/NAND2X1/schematic
subckt NAND2X1 Y A B vdd vss
    M1 (Y B vdd vdd) pch w=4u l=1u
    M0 (Y A vdd vdd) pch w=4u l=1u
    M3 (net6 A vss vss) nch w=2u l=1u wf=2
    M2 (Y B net6 net6) nch w=2u l=1u wf=2
ends NAND2X1

// KISTA_SOI_STDLIB/DFFX1/schematic
subckt DFFX1 Q QN CK D vdd vss
    M26 (QN net055 vss vss) nch w=2u l=1u wf=2
    M25 (net055 qbint vss vss) nch w=2u l=1u wf=2
    M23 (Q qbint vss vss) nch w=2u l=1u wf=2
    M19 (n30 CKb net028 net028) nch w=2u l=1u wf=2
    M18 (net028 qbint vss vss) nch w=2u l=1u wf=2
    M17 (qbint n30 vss vss) nch w=2u l=1u wf=2
    M15 (n30 CKbb mout mout) nch w=2u l=1u wf=2
    M11 (n20 CKbb net017 net017) nch w=2u l=1u wf=2
    M10 (net017 mout vss vss) nch w=2u l=1u wf=2
    M9 (mout n20 vss vss) nch w=2u l=1u wf=2
    M5 (n20 CKb net13 net13) nch w=2u l=1u wf=2
    M4 (net13 D vss vss) nch w=2u l=1u wf=2
    M3 (CKbb CKb vss vss) nch w=2u l=1u wf=2
    M0 (CKb CK vss vss) nch w=2u l=1u wf=2
    M27 (QN net055 vdd vdd) pch w=4u l=1u
    M24 (net055 qbint vdd vdd) pch w=4u l=1u
    M22 (Q qbint vdd vdd) pch w=4u l=1u
    M21 (n30 CKbb net029 net029) pch w=4u l=1u
    M20 (net029 qbint vdd vdd) pch w=4u l=1u
    M16 (qbint n30 vdd vdd) pch w=4u l=1u
    M14 (n30 CKb mout mout) pch w=4u l=1u
    M13 (n20 CKb net018 net018) pch w=4u l=1u
    M12 (net018 mout vdd vdd) pch w=4u l=1u
    M8 (mout n20 vdd vdd) pch w=4u l=1u
    M7 (n20 CKbb net14 net14) pch w=4u l=1u
    M6 (net14 D vdd vdd) pch w=4u l=1u
    M2 (CKbb CKb vdd vdd) pch w=4u l=1u
    M1 (CKb CK vdd vdd) pch w=4u l=1u
ends DFFX1

// KISTA_SOI_STDLIB/TIEHI/schematic
subckt TIEHI Y vdd vss
    M0 (net7 net7 vss vss) nch w=2u l=1u wf=2
    M1 (Y net7 vdd vdd) pch w=4u l=1u
ends TIEHI

// KISTA_SOI_STDLIB/TIELO/schematic
subckt TIELO Y vss vdd
    M0 (Y net25 vss vss) nch w=2u l=1u wf=2
    M1 (net25 net25 vdd vdd) pch w=4u l=1u
ends TIELO

// KISTA_SOI_STDLIB/timing/schematic
I0 (net1 net2 vdd vss) INVX1
I1 (net3 net4 net5 vss vdd) NOR2X1
I2 (net6 net7 vdd vss) BUFX2
I3 (net8 net9 net10 vdd vss) NAND2X1
I5 (net11 net12 net13 net14 vdd vss) DFFX1
I6 (net15 vdd vss) TIEHI
I7 (net16 vss vdd) TIELO
simulatorOptions options temp=27
