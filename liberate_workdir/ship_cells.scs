// Design: KISTA_SOI_STDLIB/timing
simulator lang=spectre
global 0 VSS! VDD!

// KISTA_SOI_STDLIB/INVX1/schematic
subckt INVX1_schematic Y A inh_VDD inh_VSS
    M0 (Y A inh_VSS inh_VSS) nch w=2u l=1u wf=2
    M1 (Y A inh_VDD inh_VDD) pch w=4u l=1u
ends INVX1_schematic

// KISTA_SOI_STDLIB/NOR2X1/schematic
subckt NOR2X1_schematic Y A B inh_VSS inh_VDD
    M1 (net9 A inh_VDD inh_VDD) pch w=4u l=1u
    M0 (Y B net9 net9) pch w=4u l=1u
    M3 (Y A inh_VSS inh_VSS) nch w=2u l=1u wf=2
    M2 (Y B inh_VSS inh_VSS) nch w=2u l=1u wf=2
ends NOR2X1_schematic

// KISTA_SOI_STDLIB/BUFX2/schematic
subckt BUFX2_schematic Y A inh_VDD inh_VSS
    M1 (Y net6 inh_VSS inh_VSS) nch w=4u l=1u wf=4.000
    M0 (net6 A inh_VSS inh_VSS) nch w=2u l=1u wf=2
    M3 (Y net6 inh_VDD inh_VDD) pch w=8u l=1u
    M2 (net6 A inh_VDD inh_VDD) pch w=4u l=1u
ends BUFX2_schematic

// KISTA_SOI_STDLIB/NAND2X1/schematic
subckt NAND2X1_schematic Y A B inh_VDD inh_VSS
    M1 (Y B inh_VDD inh_VDD) pch w=4u l=1u
    M0 (Y A inh_VDD inh_VDD) pch w=4u l=1u
    M3 (net6 A inh_VSS inh_VSS) nch w=2u l=1u wf=2
    M2 (Y B net6 net6) nch w=2u l=1u wf=2
ends NAND2X1_schematic

// KISTA_SOI_STDLIB/DFFX1/schematic
subckt DFFX1_schematic Q QN CK D inh_VDD inh_VSS
    M26 (QN net055 inh_VSS inh_VSS) nch w=2u l=1u wf=2
    M25 (net055 qbint inh_VSS inh_VSS) nch w=2u l=1u wf=2
    M23 (Q qbint inh_VSS inh_VSS) nch w=2u l=1u wf=2
    M19 (n30 CKb net028 net028) nch w=2u l=1u wf=2
    M18 (net028 qbint inh_VSS inh_VSS) nch w=2u l=1u wf=2
    M17 (qbint n30 inh_VSS inh_VSS) nch w=2u l=1u wf=2
    M15 (n30 CKbb mout mout) nch w=2u l=1u wf=2
    M11 (n20 CKbb net017 net017) nch w=2u l=1u wf=2
    M10 (net017 mout inh_VSS inh_VSS) nch w=2u l=1u wf=2
    M9 (mout n20 inh_VSS inh_VSS) nch w=2u l=1u wf=2
    M5 (n20 CKb net13 net13) nch w=2u l=1u wf=2
    M4 (net13 D inh_VSS inh_VSS) nch w=2u l=1u wf=2
    M3 (CKbb CKb inh_VSS inh_VSS) nch w=2u l=1u wf=2
    M0 (CKb CK inh_VSS inh_VSS) nch w=2u l=1u wf=2
    M27 (QN net055 inh_VDD inh_VDD) pch w=4u l=1u
    M24 (net055 qbint inh_VDD inh_VDD) pch w=4u l=1u
    M22 (Q qbint inh_VDD inh_VDD) pch w=4u l=1u
    M21 (n30 CKbb net029 net029) pch w=4u l=1u
    M20 (net029 qbint inh_VDD inh_VDD) pch w=4u l=1u
    M16 (qbint n30 inh_VDD inh_VDD) pch w=4u l=1u
    M14 (n30 CKb mout mout) pch w=4u l=1u
    M13 (n20 CKb net018 net018) pch w=4u l=1u
    M12 (net018 mout inh_VDD inh_VDD) pch w=4u l=1u
    M8 (mout n20 inh_VDD inh_VDD) pch w=4u l=1u
    M7 (n20 CKbb net14 net14) pch w=4u l=1u
    M6 (net14 D inh_VDD inh_VDD) pch w=4u l=1u
    M2 (CKbb CKb inh_VDD inh_VDD) pch w=4u l=1u
    M1 (CKb CK inh_VDD inh_VDD) pch w=4u l=1u
ends DFFX1_schematic

// KISTA_SOI_STDLIB/TIEHI/schematic
subckt TIEHI Y inh_VDD inh_VSS
    M0 (net7 net7 inh_VSS inh_VSS) nch w=2u l=1u wf=2
    M1 (Y net7 inh_VDD inh_VDD) pch w=4u l=1u
ends TIEHI

// KISTA_SOI_STDLIB/TIELO/schematic
subckt TIELO Y inh_VSS inh_VDD
    M0 (Y net25 inh_VSS inh_VSS) nch w=2u l=1u wf=2
    M1 (net25 net25 inh_VDD inh_VDD) pch w=4u l=1u
ends TIELO

// KISTA_SOI_STDLIB/timing/schematic
I0 (net1 net2 VDD! VSS!) INVX1_schematic
I1 (net3 net4 net5 VSS! VDD!) NOR2X1_schematic
I2 (net6 net7 VDD! VSS!) BUFX2_schematic
I3 (net8 net9 net10 VDD! VSS!) NAND2X1_schematic
I5 (net11 net12 net13 net14 VDD! VSS!) DFFX1_schematic
I6 (net15 VDD! VSS!) TIEHI
I7 (net16 VSS! VDD!) TIELO
simulatorOptions options temp=27
