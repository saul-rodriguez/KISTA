// TIELO
simulator lang=spectre insensitive=yes
global vss vdd
subckt TIELO Y
    C1  (vss Y)  capacitor c=898.28a
    C2  (vdd vss)  capacitor c=3.84372e-15
    C4  (1 vss)  capacitor c=17.8343f
    C3  (vdd\#1 vss)  capacitor c=1.13107e-15
    C5  (net25 vss)  capacitor c=562.423a
    C6  (net25\#3 vss)  capacitor c=985.513a
    C8  (net25\#2 vss)  capacitor c=4.44284e-15
    C7  (net25\#4 vss)  capacitor c=2.57283e-15
    C9  (X1_4 vss)  capacitor c=1.3251e-15
    Rc5  (Y\#1 Y)  resistor r=5
    Rc7  (vss vss\#1)  resistor r=5.3102
    Rc6  (vdd\#1 vdd)  resistor r=2.7054
    Rs1  (1 vss)  resistor r=50
    Rc1  (net25 net25\#2)  resistor r=7.6529
    Rd1  (net25\#3 net25\#2)  resistor r=357.2892
    Rd2  (net25\#2 net25\#4)  resistor r=1827.2892
    MX1_M0_unmatched  (net25 net25\#3 vdd\#1 vdd\#1)  pch w=4e-06 l=1e-06 \
        as=0 ad=1e-11 ps=0 pd=1.3e-05 sa=2e-06 sb=2e-06
    MX0_M0_unmatched  (Y\#1 net25\#4 vss\#1 vss\#1)  nch w=2e-06 l=1e-06 \
        as=0 ad=5e-12 ps=0 pd=9e-06 sa=2e-06 sb=2e-06
ends TIELO
