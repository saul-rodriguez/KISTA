// DFFSRX1
simulator lang=spectre insensitive=yes
global vss vdd
subckt DFFSRX1 D Q SN QN RN CK
    C22  (RN\#2 vss)  capacitor c=10.3983a
    C276  (RN\#2 13)  capacitor c=1.92504e-15
    C33  (vss\#2 CK\#6)  capacitor c=66.411a
    C380  (CK\#6 13)  capacitor c=776.18a
    C317  (vdd\#4 Y3\#6)  capacitor c=37.5839a
    C15  (SN\#6 vss)  capacitor c=7.29998e-19
    C32  (CK\#2 vss)  capacitor c=5.9e-18
    C34  (vss\#2 CK\#5)  capacitor c=209.25a
    C35  (vss\#4 CK)  capacitor c=115.296a
    C40  (RNi\#2312 vss)  capacitor c=10.8151a
    C41  (RNi\#2311 vss)  capacitor c=86.3749a
    C46  (RNi\#5 vss)  capacitor c=2.981e-18
    C54  (Y4\#8 vss)  capacitor c=55.4545a
    C55  (Y4\#2312 vss)  capacitor c=7.97704e-18
    C59  (Y4\#2 vss)  capacitor c=2.33591e-18
    C70  (Y2\#2317 vss)  capacitor c=16.3148a
    C85  (vss\#4 13)  capacitor c=129.678f
    C182  (SN\#6 CK)  capacitor c=308.055a
    C185  (CK\#2 SN\#6)  capacitor c=3.45997e-20
    C191  (SN\#6 RNi\#3)  capacitor c=650.544a
    C193  (RNi\#5 SN\#6)  capacitor c=1.06807e-20
    C222  (SN\#6 13)  capacitor c=5.82465e-15
    C284  (vdd\#1 RNi\#2312)  capacitor c=150.299a
    C290  (Y4\#2312 vdd\#1)  capacitor c=88.5389a
    C347  (RNi\#2311 CK)  capacitor c=27.2181a
    C348  (RNi\#2311 CK\#5)  capacitor c=761.554a
    C351  (CK\#2 RNi\#3)  capacitor c=607.941a
    C352  (RNi\#5 CK)  capacitor c=1.06046e-19
    C353  (RNi\#5 CK\#2)  capacitor c=5.14917e-18
    C382  (CK\#5 13)  capacitor c=35.4512f
    C383  (CK\#2 13)  capacitor c=5.89787e-15
    C427  (RNi\#2311 Y4\#8)  capacitor c=1.68054e-15
    C428  (RNi\#3 Y4\#8)  capacitor c=733.745a
    C429  (Y4\#2312 RNi\#2312)  capacitor c=664.727a
    C431  (Y4\#2 RNi\#3)  capacitor c=30.9075a
    C432  (RNi\#5 Y4\#8)  capacitor c=253.305a
    C433  (RNi\#5 Y4\#2)  capacitor c=10.67a
    C442  (RNi\#2311 Y2\#2317)  capacitor c=1.63206e-15
    C446  (RNi\#3 Y2\#2317)  capacitor c=802.729a
    C449  (RNi\#5 Y2\#2317)  capacitor c=11.1405a
    C461  (RNi\#2312 13)  capacitor c=2.39827e-15
    C467  (RNi\#2311 13)  capacitor c=49.4757f
    C468  (RNi\#5 13)  capacitor c=5.76825e-15
    C493  (Y2\#2317 Y4\#8)  capacitor c=3.91366e-15
    C516  (Y4\#8 13)  capacitor c=55.4148f
    C553  (Y2\#2317 13)  capacitor c=33.1577f
    C1  (D vss)  capacitor c=19.9141a
    C114  (RNi\#2311 D)  capacitor c=55.6601a
    C122  (13 D)  capacitor c=1.52503e-15
    C2  (D\#2 vss)  capacitor c=5.71744e-19
    C113  (D\#2 RNi\#2312)  capacitor c=33.9973a
    C123  (D\#2 13)  capacitor c=1.06759e-15
    C4  (D\#3 vss)  capacitor c=5.31018e-18
    C115  (D\#3 RNi\#2311)  capacitor c=571.177a
    C125  (D\#3 13)  capacitor c=5.79577e-15
    C5  (Q vss)  capacitor c=21.1936a
    C145  (CK Q)  capacitor c=623.077a
    C148  (CK\#2 Q)  capacitor c=19.1482a
    C150  (RNi\#2311 Q)  capacitor c=1.1553e-15
    C156  (Y2\#2317 Q)  capacitor c=484.263a
    C6  (Q\#2310 vss)  capacitor c=7.36429e-18
    C163  (Q\#2310 13)  capacitor c=177.251a
    C7  (Q\#2311 vss)  capacitor c=1.32412e-18
    C155  (Q\#2311 Y4\#8)  capacitor c=588.712a
    C161  (Q\#2311 Y2\#2317)  capacitor c=543.205a
    C166  (Q\#2311 13)  capacitor c=5.79806e-15
    C8  (vss\#2 Q\#2312)  capacitor c=61.6419a
    C146  (CK\#5 Q\#2312)  capacitor c=599.412a
    C151  (RNi\#2311 Q\#2312)  capacitor c=609.757a
    C164  (Q\#2312 13)  capacitor c=4.28371e-15
    C9  (vss\#4 Q\#3)  capacitor c=156.13a
    C147  (Q\#3 CK)  capacitor c=617.924a
    C10  (SN\#7 vss)  capacitor c=12.4308a
    C197  (Y4\#8 SN\#7)  capacitor c=10.3472a
    C200  (Y4\#2 SN\#7)  capacitor c=4.35853e-19
    C215  (SN\#7 13)  capacitor c=3.05409e-15
    C11  (SN\#1 vss)  capacitor c=14.2235a
    C216  (SN\#1 13)  capacitor c=1.28298e-15
    C12  (SN\#4 vss)  capacitor c=62.8601a
    C180  (SN\#4 CK)  capacitor c=576.195a
    C219  (SN\#4 13)  capacitor c=1.99514e-15
    C13  (SN\#9 vss)  capacitor c=25.7229a
    C181  (SN\#9 CK)  capacitor c=1.95035e-15
    C184  (CK\#2 SN\#9)  capacitor c=621.277a
    C192  (RNi\#5 SN\#9)  capacitor c=611.509a
    C209  (SN\#9 Y2\#2317)  capacitor c=814.835a
    C220  (SN\#9 13)  capacitor c=26.3378f
    C16  (vss\#4 SN\#2310)  capacitor c=61.2785a
    C178  (SN\#2310 CK)  capacitor c=278.279a
    C183  (CK\#2 SN\#2310)  capacitor c=4.29376e-18
    C217  (SN\#2310 13)  capacitor c=1.3606e-15
    C17  (QN\#5 vss)  capacitor c=3.19218e-18
    C246  (Y4\#8 QN\#5)  capacitor c=589.783a
    C250  (Y2\#2317 QN\#5)  capacitor c=544.041a
    C259  (QN\#5 13)  capacitor c=4.20264e-15
    C18  (QN\#7 vss)  capacitor c=12.1951a
    C19  (vss\#2 QN\#6)  capacitor c=72.6356a
    C240  (QN\#6 CK\#5)  capacitor c=68.4719a
    C20  (vss\#4 QN\#4)  capacitor c=494.068a
    C134  (Q\#3 QN\#4)  capacitor c=242.567a
    C237  (QN\#4 CK)  capacitor c=585.92a
    C241  (CK\#2 QN\#4)  capacitor c=9.04055e-18
    C243  (RNi\#2311 QN\#4)  capacitor c=610.548a
    C260  (QN\#4 13)  capacitor c=5.89427e-15
    C21  (vss\#4 QN\#3)  capacitor c=618.325a
    C135  (Q\#3 QN\#3)  capacitor c=108.661a
    C239  (QN\#3 CK\#5)  capacitor c=560.201a
    C244  (QN\#3 RNi\#2311)  capacitor c=10.2195a
    C251  (QN\#3 Y2\#2317)  capacitor c=4.54541e-18
    C261  (QN\#3 13)  capacitor c=5.5832e-15
    C26  (vdd\#3 vss)  capacitor c=108.756a
    C295  (vdd\#3 Y4\#8)  capacitor c=24.5998a
    C319  (vdd\#3 13)  capacitor c=135.848f
    C27  (CK\#8 vss)  capacitor c=3.08637e-18
    C356  (Y4\#8 CK\#8)  capacitor c=603.761a
    C378  (CK\#8 13)  capacitor c=3.57615e-15
    C28  (CK\#1 vss)  capacitor c=4.98943e-19
    C357  (Y4\#8 CK\#1)  capacitor c=589.934a
    C358  (Y4\#2 CK\#1)  capacitor c=24.8498a
    C379  (CK\#1 13)  capacitor c=3.52929e-15
    C29  (vss\#2311 CK)  capacitor c=94.7312a
    C30  (vss\#2312 CK)  capacitor c=94.7312a
    C31  (vss\#2313 CK)  capacitor c=95.7291a
    C14  (vss\#2313 SN\#8)  capacitor c=179.76a
    C89  (vss\#6 net8\#2)  capacitor c=105.554a
    C179  (SN\#8 CK)  capacitor c=282.751a
    C218  (SN\#8 13)  capacitor c=1.31003e-15
    C224  (net8\#2 SN\#8)  capacitor c=83.616a
    C225  (SN\#6 net8\#2)  capacitor c=1.83588e-18
    C387  (net8\#2 CK)  capacitor c=60.7985a
    C586  (net8\#2 13)  capacitor c=220.425a
    C88  (vss\#6 net8)  capacitor c=73.7603a
    C386  (net8 CK)  capacitor c=68.4719a
    C585  (net8 13)  capacitor c=221.122a
    C36  (vss\#4 CK\#3)  capacitor c=61.2785a
    C381  (CK\#3 13)  capacitor c=776.506a
    C37  (net13\#5 vss)  capacitor c=9.39651e-18
    C418  (net13\#5 13)  capacitor c=1.28657e-15
    C39  (net13\#3 vss)  capacitor c=138.401a
    C342  (net13\#3 CK)  capacitor c=56.3348a
    C420  (net13\#3 13)  capacitor c=1.08667e-15
    C43  (vss\#2312 RNi\#6)  capacitor c=179.406a
    C94  (vss\#4 net10)  capacitor c=103.983a
    C345  (RNi\#6 CK)  capacitor c=566.617a
    C350  (CK\#2 RNi\#6)  capacitor c=8.74272e-18
    C395  (net10 CK)  capacitor c=67.4315a
    C466  (RNi\#6 13)  capacitor c=1.98416e-15
    C472  (RNi\#6 net10)  capacitor c=83.616a
    C591  (net10 13)  capacitor c=221.122a
    C95  (vss\#4 net10\#2)  capacitor c=73.7811a
    C396  (net10\#2 CK)  capacitor c=63.0371a
    C397  (net10\#2 CK\#3)  capacitor c=83.616a
    C398  (CK\#2 net10\#2)  capacitor c=15.1599a
    C592  (net10\#2 13)  capacitor c=221.343a
    C44  (RNi\#2318 vss)  capacitor c=12.9931a
    C189  (RNi\#2318 SN\#1)  capacitor c=246.055a
    C45  (RNi\#2317 vss)  capacitor c=18.7788a
    C416  (RNi\#2317 net13\#5)  capacitor c=244.284a
    C47  (RNi\#9 vss)  capacitor c=6.83588e-18
    C434  (RNi\#9 Y4\#8)  capacitor c=242.121a
    C453  (RNi\#9 Y2\#2317)  capacitor c=598.126a
    C469  (RNi\#9 13)  capacitor c=5.83607e-15
    C48  (RNi\#2313 vss)  capacitor c=8.6169e-18
    C116  (RNi\#2313 D)  capacitor c=10.0198a
    C118  (Y4\#2313 D)  capacitor c=55.7344a
    C56  (Y4\#2313 vss)  capacitor c=5.7836e-18
    C117  (RNi\#2313 D\#3)  capacitor c=12.6982a
    C119  (Y4\#2313 D\#2)  capacitor c=434.763a
    C120  (D\#3 Y4\#2313)  capacitor c=276.353a
    C124  (D\#4 13)  capacitor c=3.50057e-15
    C435  (RNi\#2313 Y4\#8)  capacitor c=36.6002a
    C470  (RNi\#2313 13)  capacitor c=6.2037e-15
    C478  (RNi\#2312 X53_5)  capacitor c=487.384a
    C320  (vdd\#1 X53_5)  capacitor c=462.948a
    C521  (Y4\#2312 X53_5)  capacitor c=406.381a
    C112  (vdd\#22 D\#2)  capacitor c=155.241a
    C291  (Y4\#2313 vdd\#22)  capacitor c=107.65a
    C321  (vdd\#22 X52_5)  capacitor c=328.32a
    C522  (Y4\#2313 X52_5)  capacitor c=315.034a
    C128  (D\#2 X52_5)  capacitor c=453.96a
    C121  (Y3\#2313 D\#2)  capacitor c=36.2792a
    C78  (Y3\#2313 vss)  capacitor c=4.49724e-18
    C568  (Y3\#2313 13)  capacitor c=184.717a
    C3  (vss\#1 D\#4)  capacitor c=66.411a
    C42  (vss\#1 RNi\#2314)  capacitor c=184.219a
    C464  (RNi\#2314 13)  capacitor c=2.08589e-15
    C49  (vss\#2 RNi\#2310)  capacitor c=61.2785a
    C346  (CK\#5 RNi\#2310)  capacitor c=595.066a
    C465  (RNi\#2310 13)  capacitor c=1.97064e-15
    C149  (Q\#2310 RNi\#8)  capacitor c=33.8606a
    C425  (Y4\#8 RNi\#8)  capacitor c=349.436a
    C462  (RNi\#8 13)  capacitor c=2.27235e-15
    C50  (vss\#6 RNi)  capacitor c=169.124a
    C343  (RNi CK)  capacitor c=1.09018e-15
    C51  (vss\#6 RNi\#2)  capacitor c=73.7811a
    C188  (RNi\#2 SN\#4)  capacitor c=80.8146a
    C349  (RNi\#2 CK)  capacitor c=68.4915a
    C52  (Y4\#7 vss)  capacitor c=4.07716e-18
    C355  (CK\#8 Y4\#7)  capacitor c=34.5781a
    C513  (Y4\#7 13)  capacitor c=1.12362e-15
    C53  (Y4\#3 vss)  capacitor c=1.32962e-18
    C195  (SN\#7 Y4\#3)  capacitor c=34.5781a
    C514  (Y4\#3 13)  capacitor c=1.06092e-15
    C57  (Y4\#2315 vss)  capacitor c=8.32077e-18
    C503  (Y4\#2315 Y3\#2313)  capacitor c=148.356a
    C58  (Y4\#2311 vss\#1)  capacitor c=163.905a
    C60  (vss\#2 Y4\#5)  capacitor c=69.8273a
    C515  (Y4\#5 13)  capacitor c=3.63097e-15
    C61  (vss\#6 Y4)  capacitor c=61.3093a
    C198  (SN\#6 Y4)  capacitor c=2.52051e-18
    C354  (Y4 CK)  capacitor c=575.996a
    C512  (13 Y4)  capacitor c=3.17114e-15
    C517  (net8 Y4)  capacitor c=83.616a
    C62  (Y1\#9 vss)  capacitor c=7.40801e-18
    C360  (Y1\#9 CK\#1)  capacitor c=33.8606a
    C533  (Y1\#9 13)  capacitor c=177.251a
    C63  (Y1\#8 vss)  capacitor c=34.1498a
    C203  (Y1\#8 SN\#7)  capacitor c=639.704a
    C439  (RNi\#2318 Y1\#8)  capacitor c=24.6736a
    C64  (vss\#4 Y1\#2311)  capacitor c=59.6561a
    C205  (SN\#6 Y1\#2311)  capacitor c=2.58005e-18
    C361  (Y1\#2311 CK)  capacitor c=567.131a
    C364  (CK\#2 Y1\#2311)  capacitor c=8.75064e-18
    C437  (RNi\#3 Y1\#2311)  capacitor c=604.668a
    C440  (RNi\#5 Y1\#2311)  capacitor c=5.12337e-18
    C534  (Y1\#2311 13)  capacitor c=4.14436e-15
    C65  (vss\#6 Y1)  capacitor c=91.675a
    C204  (SN\#6 Y1)  capacitor c=4.59625e-18
    C359  (Y1 CK)  capacitor c=1.06846e-15
    C363  (CK\#2 Y1)  capacitor c=17.4697a
    C436  (RNi\#3 Y1)  capacitor c=519.815a
    C66  (vss\#6 Y1\#2)  capacitor c=64.4553a
    C362  (Y1\#2 CK)  capacitor c=63.7563a
    C67  (Y2\#20 vss)  capacitor c=3.8424e-18
    C365  (Y2\#20 CK\#8)  capacitor c=34.5781a
    C547  (Y2\#20 13)  capacitor c=1.68071e-15
    C68  (Y2\#2315 vss)  capacitor c=7.26522e-18
    C548  (Y2\#2315 13)  capacitor c=1.91796e-15
    C69  (Y2\#4 vss)  capacitor c=8.35411e-18
    C491  (Y4\#3 Y2\#4)  capacitor c=34.5781a
    C492  (Y4\#8 Y2\#4)  capacitor c=589.524a
    C496  (Y4\#2 Y2\#4)  capacitor c=24.8325a
    C549  (Y2\#4 13)  capacitor c=4.44052e-15
    C71  (Y2\#6 vss)  capacitor c=1.60958e-18
    C494  (Y2\#6 Y4\#8)  capacitor c=94.915a
    C497  (Y4\#2 Y2\#6)  capacitor c=3.99811e-18
    C554  (Y2\#6 13)  capacitor c=2.99881e-15
    C73  (vss\#2311 Y2\#2313)  capacitor c=179.398a
    C97  (vss\#4 net3\#2)  capacitor c=104.004a
    C208  (SN\#9 Y2\#2313)  capacitor c=288.854a
    C366  (Y2\#2313 CK)  capacitor c=567.425a
    C372  (CK\#2 Y2\#2313)  capacitor c=8.75519e-18
    C400  (net3\#2 CK)  capacitor c=67.4508a
    C401  (CK\#2 net3\#2)  capacitor c=1.96429e-18
    C551  (Y2\#2313 13)  capacitor c=2.54149e-15
    C559  (net3\#2 Y2\#2313)  capacitor c=83.616a
    C160  (Y2\#2314 Q)  capacitor c=75.9005a
    C162  (Q\#2311 Y2\#2314)  capacitor c=42.5849a
    C213  (Y2\#2314 SN\#9)  capacitor c=63.8795a
    C252  (Y2\#2314 QN\#5)  capacitor c=42.6504a
    C253  (Y2\#2314 QN\#3)  capacitor c=3.5634e-19
    C451  (Y2\#2314 RNi\#3)  capacitor c=89.019a
    C452  (Y2\#2314 RNi\#5)  capacitor c=8.73366e-19
    C498  (Y2\#2314 Y4\#8)  capacitor c=74.0073a
    C499  (Y2\#2314 Y4\#2)  capacitor c=3.11741e-18
    C594  (net3\#2 13)  capacitor c=221.343a
    C96  (vss\#4 net3)  capacitor c=73.7603a
    C226  (SN\#2310 net3)  capacitor c=83.616a
    C227  (SN\#9 net3)  capacitor c=1.83588e-18
    C399  (net3 CK)  capacitor c=59.8553a
    C593  (net3 13)  capacitor c=220.204a
    C255  (QN\#2311 Y2\#2314)  capacitor c=75.5441a
    C248  (QN\#2311 Y4\#8)  capacitor c=1.23924e-15
    C254  (QN\#2311 Y2\#2317)  capacitor c=483.91a
    C74  (vss\#4 Y2\#5)  capacitor c=73.7603a
    C371  (Y2\#5 CK)  capacitor c=67.4315a
    C375  (CK\#2 Y2\#5)  capacitor c=1.04045e-18
    C529  (Y2\#5 Y1\#2311)  capacitor c=80.8146a
    C75  (vss\#6 Y2\#3)  capacitor c=489.667a
    C211  (SN\#6 Y2\#3)  capacitor c=2.58204e-18
    C367  (Y2\#3 CK)  capacitor c=562.488a
    C373  (CK\#2 Y2\#3)  capacitor c=8.679e-18
    C445  (RNi\#3 Y2\#3)  capacitor c=610.552a
    C531  (Y1\#2 Y2\#3)  capacitor c=139.082a
    C552  (Y2\#3 13)  capacitor c=5.78719e-15
    C76  (vss\#6 Y2\#2)  capacitor c=614.384a
    C212  (SN\#6 Y2\#2)  capacitor c=4.59649e-18
    C187  (RNi\#3 SN)  capacitor c=3.79181e-15
    C194  (Y4 SN)  capacitor c=570.21a
    C201  (Y1 SN)  capacitor c=1.0398e-15
    C202  (Y1\#2311 SN)  capacitor c=583.681a
    C207  (Y2\#3 SN)  capacitor c=584.131a
    C210  (Y2\#2 SN)  capacitor c=1.03986e-15
    C369  (Y2\#2 CK)  capacitor c=1.06264e-15
    C374  (CK\#2 Y2\#2)  capacitor c=16.3962a
    C447  (RNi\#3 Y2\#2)  capacitor c=517.839a
    C450  (RNi\#5 Y2\#2)  capacitor c=4.38766e-18
    C526  (Y2\#2 Y1)  capacitor c=105.372a
    C438  (RNi\#3 Y1\#3)  capacitor c=554.355a
    C441  (RNi\#5 Y1\#3)  capacitor c=4.51285e-18
    C344  (CK\#1 RNi\#4)  capacitor c=34.5781a
    C426  (Y4\#8 RNi\#4)  capacitor c=335.406a
    C430  (Y4\#2 RNi\#4)  capacitor c=14.1283a
    C443  (Y2\#6 RNi\#4)  capacitor c=15.3669a
    C463  (RNi\#4 13)  capacitor c=2.30249e-15
    C484  (Y1\#3 Y4\#8)  capacitor c=1.12322e-15
    C488  (Y4\#2 Y1\#3)  capacitor c=66.5048a
    C535  (Y1\#3 13)  capacitor c=19.1731f
    C555  (Y2\#2 13)  capacitor c=9.88464e-15
    C174  (SN\#2312 QN\#5)  capacitor c=34.5781a
    C196  (Y4\#8 SN\#2312)  capacitor c=566.375a
    C199  (Y4\#2 SN\#2312)  capacitor c=23.8574a
    C206  (Y2\#2315 SN\#2312)  capacitor c=36.2794a
    C214  (SN\#2312 13)  capacitor c=2.85775e-15
    C77  (Y3 vss)  capacitor c=2.3736e-18
    C256  (QN\#7 Y3)  capacitor c=28.8734a
    C500  (Y4\#8 Y3)  capacitor c=98.7308a
    C544  (Y2\#20 Y3)  capacitor c=15.515a
    C567  (13 Y3)  capacitor c=2.98824e-15
    C79  (Y3\#6 vss)  capacitor c=17.9549a
    C457  (RNi\#2311 Y3\#6)  capacitor c=544.806a
    C502  (Y4\#8 Y3\#6)  capacitor c=1.37785e-15
    C572  (Y3\#6 13)  capacitor c=19.6975f
    C80  (vss\#1 Y3\#2315)  capacitor c=65.6319a
    C455  (RNi\#2311 Y3\#2315)  capacitor c=603.402a
    C459  (RNi\#2313 Y3\#2315)  capacitor c=13.4146a
    C460  (RNi\#2313 Y3\#5)  capacitor c=24.2368a
    C84  (vss\#2 Y3\#5)  capacitor c=181.602a
    C458  (Y3\#5 RNi\#2311)  capacitor c=545.39a
    C504  (Y4\#2311 Y3\#2315)  capacitor c=95.5625a
    C507  (Y3\#5 Y4\#5)  capacitor c=95.5608a
    C508  (Y3\#5 Y4\#2311)  capacitor c=139.797a
    C570  (Y3\#2315 13)  capacitor c=4.5824e-15
    C81  (Y3\#2311 vss)  capacitor c=1.42055e-18
    C510  (Y3\#2311 Y4\#8)  capacitor c=134.092a
    C546  (Y3\#2311 Y2\#20)  capacitor c=637.65a
    C83  (Y3\#2314 vss)  capacitor c=6.14541e-18
    C316  (vdd\#3 Y3\#2314)  capacitor c=18.2136a
    C511  (Y3\#2314 Y4\#2315)  capacitor c=703.543a
    C573  (Y3\#2314 13)  capacitor c=5.87633e-15
    C578  (Y3\#2314 X51_5)  capacitor c=96.1789a
    C523  (Y4\#2315 X51_5)  capacitor c=348.52a
    C577  (Y3\#2313 X51_5)  capacitor c=356.549a
    C322  (vdd\#23 X51_5)  capacitor c=333.968a
    C292  (Y4\#2315 vdd\#23)  capacitor c=115.933a
    C311  (vdd\#23 Y3\#2313)  capacitor c=144.16a
    C86  (net14 vss)  capacitor c=72.6356a
    C223  (SN\#4 net14)  capacitor c=83.616a
    C384  (net14 CK)  capacitor c=68.4719a
    C471  (RNi\#2 net14)  capacitor c=41.361a
    C190  (SN\#2 RNi\#3)  capacitor c=8.00856e-19
    C444  (RNi\#3 Y2)  capacitor c=552.238a
    C221  (SN\#2 13)  capacitor c=5.93481e-18
    C495  (Y4\#2 Y2)  capacitor c=94.8866a
    C527  (Y1\#3 Y2)  capacitor c=140.807a
    C583  (net14 13)  capacitor c=221.122a
    C87  (net14\#2 vss)  capacitor c=105.129a
    C385  (net14\#2 CK)  capacitor c=68.4915a
    C584  (net14\#2 13)  capacitor c=221.343a
    C186  (net13 SN)  capacitor c=34.8887a
    C228  (net4\#2 SN\#2310)  capacitor c=83.616a
    C611  (net4\#2 net3)  capacitor c=39.8112a
    C392  (CK\#3 net9)  capacitor c=83.616a
    C610  (net10\#2 net9)  capacitor c=39.8112a
    C154  (Y4\#2 Q\#7)  capacitor c=10.3532a
    C490  (Y1\#2310 Y4\#2)  capacitor c=24.7525a
    C159  (Q\#9 Y2\#6)  capacitor c=28.8734a
    C309  (vdd\#2313 Y2\#6)  capacitor c=29.9985a
    C130  (QN Q)  capacitor c=80.0008a
    C262  (QN\#4 net4)  capacitor c=83.616a
    C264  (QN\#6 net5\#2)  capacitor c=39.8112a
    C263  (net5\#2 QN\#3)  capacitor c=1.83462e-18
    C422  (net14\#2 net13\#7)  capacitor c=83.616a
    C302  (vdd\#2316 Y1\#3)  capacitor c=41.1742a
    C575  (Y3\#5 net12)  capacitor c=41.34a
    C475  (RNi\#2314 net2)  capacitor c=83.616a
    C293  (vdd\#24 Y4\#7)  capacitor c=158.19a
    C312  (Y3\#7 vdd\#24)  capacitor c=111.119a
    C505  (Y3\#7 Y4\#7)  capacitor c=438.63a
    C165  (Q\#4 13)  capacitor c=20.0429f
    C137  (QN\#2311 Q\#4)  capacitor c=117.734a
    C142  (vdd\#9 Q\#4)  capacitor c=10.9119a
    C236  (vdd\#9 QN\#2311)  capacitor c=30.4203a
    C143  (vdd\#9 Q\#2311)  capacitor c=28.7505a
    C136  (Q\#2311 QN\#2310)  capacitor c=609.217a
    C170  (Q\#2311 X45_5)  capacitor c=112.751a
    C267  (QN\#2310 X45_5)  capacitor c=316.116a
    C132  (QN\#2310 Q\#2310)  capacitor c=147.723a
    C169  (Q\#2310 X45_5)  capacitor c=356.549a
    C328  (vdd\#29 X45_5)  capacitor c=333.968a
    C138  (vdd\#29 Q\#2310)  capacitor c=144.16a
    C234  (QN\#2310 vdd\#29)  capacitor c=111.825a
    C247  (QN\#2310 Y4\#8)  capacitor c=289.068a
    C152  (Q\#4 Y4\#8)  capacitor c=1.2172e-15
    C506  (Y3\#7 Y4\#8)  capacitor c=413.366a
    C144  (vdd\#2310 Q\#4)  capacitor c=41.1742a
    C153  (Q\#7 Y4\#8)  capacitor c=327.485a
    C129  (Q\#7 SN\#2312)  capacitor c=644.683a
    C140  (Q\#7 vdd\#31)  capacitor c=107.267a
    C175  (vdd\#31 SN\#2312)  capacitor c=158.19a
    C229  (SN\#2312 X43_5)  capacitor c=453.221a
    C172  (Q\#7 X43_5)  capacitor c=316.082a
    C330  (vdd\#31 X43_5)  capacitor c=328.08a
    C139  (Q\#5 vdd\#30)  capacitor c=110.665a
    C133  (Q\#5 QN\#5)  capacitor c=672.681a
    C235  (vdd\#30 QN\#5)  capacitor c=158.19a
    C268  (QN\#5 X44_5)  capacitor c=453.221a
    C329  (vdd\#30 X44_5)  capacitor c=333.968a
    C171  (Q\#5 X44_5)  capacitor c=316.042a
    C489  (Y1\#2310 Y4\#8)  capacitor c=587.624a
    C536  (Y1\#2310 13)  capacitor c=5.9638e-15
    C141  (Q\#9 vdd\#32)  capacitor c=86.3337a
    C157  (Q\#4 Y2\#2317)  capacitor c=483.91a
    C158  (Q\#9 Y2\#2315)  capacitor c=613.811a
    C304  (vdd\#32 Y2\#2315)  capacitor c=160.516a
    C331  (vdd\#32 X42_5)  capacitor c=333.024a
    C562  (Y2\#2315 X42_5)  capacitor c=461.773a
    C173  (Q\#9 X42_5)  capacitor c=156.865a
    C249  (Y2\#2317 QN)  capacitor c=479.717a
    C258  (13 QN)  capacitor c=14.3931f
    C131  (Q\#2312 QN)  capacitor c=185.105a
    C167  (Q\#3 net4)  capacitor c=41.34a
    C595  (net4 13)  capacitor c=221.122a
    C98  (vss\#4 net4)  capacitor c=72.6356a
    C92  (vss\#4 net9)  capacitor c=73.7603a
    C589  (net9 13)  capacitor c=221.122a
    C93  (vss\#4 net9\#2)  capacitor c=72.6564a
    C590  (net9\#2 13)  capacitor c=221.343a
    C99  (vss\#4 net4\#2)  capacitor c=73.7811a
    C596  (net4\#2 13)  capacitor c=221.343a
    C402  (net4 CK)  capacitor c=67.4315a
    C391  (net9 CK)  capacitor c=67.4315a
    C393  (net9\#2 CK)  capacitor c=67.4508a
    C403  (net4\#2 CK)  capacitor c=67.4508a
    C82  (vss\#2310 Y3\#3)  capacitor c=179.995a
    C571  (Y3\#3 13)  capacitor c=4.43765e-15
    C168  (net5\#2 Q\#2312)  capacitor c=83.616a
    C598  (net5\#2 13)  capacitor c=221.343a
    C101  (vss\#2 net5\#2)  capacitor c=72.6564a
    C102  (vss\#2 net6)  capacitor c=103.983a
    C574  (Y3\#3 net6)  capacitor c=83.616a
    C599  (net6 13)  capacitor c=221.122a
    C100  (vss\#2 net5)  capacitor c=73.7603a
    C597  (net5 13)  capacitor c=221.122a
    C103  (vss\#2 net6\#2)  capacitor c=73.7811a
    C600  (net6\#2 13)  capacitor c=221.343a
    C612  (net6\#2 net5)  capacitor c=39.8112a
    C407  (CK\#5 net6)  capacitor c=68.4719a
    C238  (CK\#5 QN)  capacitor c=617.785a
    C376  (CK\#5 Y3\#3)  capacitor c=597.152a
    C405  (CK\#5 net5)  capacitor c=68.4719a
    C406  (net5\#2 CK\#5)  capacitor c=68.4915a
    C242  (RNi\#2311 QN)  capacitor c=1.13549e-15
    C408  (net6\#2 CK\#5)  capacitor c=68.4915a
    C456  (RNi\#2311 Y3\#3)  capacitor c=590.257a
    C501  (Y4\#8 Y3\#2)  capacitor c=593.725a
    C545  (Y2\#2317 Y3\#2)  capacitor c=586.895a
    C569  (Y3\#2 13)  capacitor c=4.37242e-15
    C104  (vss\#2 net11)  capacitor c=73.7603a
    C410  (CK\#5 net11)  capacitor c=67.9406a
    C601  (net11 13)  capacitor c=221.122a
    C105  (vss\#2 net11\#2)  capacitor c=104.004a
    C411  (net11\#2 CK\#5)  capacitor c=68.4915a
    C602  (net11\#2 13)  capacitor c=221.343a
    C106  (vss\#2 net12)  capacitor c=76.0632a
    C603  (net12 13)  capacitor c=237.088a
    C107  (vss\#2 net12\#2)  capacitor c=77.2097a
    C604  (net12\#2 13)  capacitor c=237.325a
    C613  (net12\#2 net11)  capacitor c=39.8112a
    C72  (vss\#9 Y2\#2318)  capacitor c=179.398a
    C560  (net11\#2 Y2\#2318)  capacitor c=83.616a
    C368  (CK\#5 Y2\#2318)  capacitor c=600.698a
    C550  (Y2\#2318 13)  capacitor c=2.61707e-15
    C404  (CK\#2 net4\#2)  capacitor c=2.08119e-18
    C394  (CK\#2 net9\#2)  capacitor c=2.08119e-18
    C390  (CK\#2 net7)  capacitor c=1.78339e-18
    C388  (net7 CK)  capacitor c=67.4315a
    C587  (net7 13)  capacitor c=221.122a
    C90  (vss\#6 net7)  capacitor c=72.6356a
    C91  (vss\#6 net7\#2)  capacitor c=73.7811a
    C389  (net7\#2 CK)  capacitor c=67.729a
    C341  (net13\#7 CK)  capacitor c=596.878a
    C38  (vss\#2314 net13\#7)  capacitor c=179.999a
    C419  (net13\#7 13)  capacitor c=2.00319e-15
    C588  (net7\#2 13)  capacitor c=221.343a
    C233  (QN\#8 vdd\#28)  capacitor c=107.267a
    C245  (QN\#8 RNi\#8)  capacitor c=665.355a
    C285  (vdd\#28 RNi\#8)  capacitor c=155.241a
    C454  (RNi\#8 Y3\#2)  capacitor c=35.7731a
    C327  (vdd\#28 X46_5)  capacitor c=328.08a
    C479  (RNi\#8 X46_5)  capacitor c=453.221a
    C266  (QN\#8 X46_5)  capacitor c=316.082a
    C257  (QN\#7 Y3\#2)  capacitor c=636.955a
    C232  (QN\#7 vdd\#27)  capacitor c=86.3337a
    C315  (vdd\#27 Y3\#2)  capacitor c=157.571a
    C265  (QN\#7 X47_5)  capacitor c=157.049a
    C326  (vdd\#27 X47_5)  capacitor c=333.024a
    C582  (Y3\#2 X47_5)  capacitor c=461.773a
    C318  (vdd\#6 Y3)  capacitor c=29.9984a
    C275  (13 RN)  capacitor c=5.63819e-15
    C23  (vss\#8 RN)  capacitor c=25.3a
    C24  (vss\#8 RN\#4)  capacitor c=176.517a
    C277  (RN\#4 13)  capacitor c=1.46203e-15
    C25  (RN\#3 vss\#8)  capacitor c=1.28111e-18
    C278  (RN\#3 13)  capacitor c=312.694a
    C270  (net13\#3 RN)  capacitor c=64.9871a
    C272  (net13\#4 RN)  capacitor c=376.425a
    C271  (net13\#3 RN\#4)  capacitor c=170.87a
    C274  (RN\#3 net13\#4)  capacitor c=24.5239a
    C273  (net13\#4 RN\#2)  capacitor c=326.828a
    C421  (net13\#4 13)  capacitor c=3.0588e-15
    C417  (13 net13)  capacitor c=5.32012e-15
    C415  (RNi\#2317 net13)  capacitor c=749.436a
    C269  (vdd\#21 RN\#2)  capacitor c=182.997a
    C283  (net13\#4 vdd\#21)  capacitor c=100.498a
    C279  (RN\#2 X33_5)  capacitor c=509.926a
    C424  (net13\#4 X33_5)  capacitor c=175.343a
    C340  (vdd\#21 X33_5)  capacitor c=485.485a
    C289  (vdd\#20 RNi\#2317)  capacitor c=10.3692a
    C282  (vdd\#40 net13\#5)  capacitor c=183.127a
    C288  (vdd\#40 RNi\#2317)  capacitor c=112.844a
    C339  (vdd\#40 X34_5)  capacitor c=182.825a
    C423  (net13\#5 X34_5)  capacitor c=511.921a
    C483  (RNi\#2317 X34_5)  capacitor c=182.825a
    C301  (vdd\#2315 Y1\#2310)  capacitor c=28.7505a
    C300  (vdd\#2315 Y1\#3)  capacitor c=10.9119a
    C303  (vdd\#26 Y2\#20)  capacitor c=158.19a
    C310  (vdd\#2315 Y2)  capacitor c=30.4203a
    C314  (Y3\#2311 vdd\#26)  capacitor c=106.406a
    C325  (vdd\#26 X48_5)  capacitor c=333.024a
    C561  (Y2\#20 X48_5)  capacitor c=453.221a
    C581  (Y3\#2311 X48_5)  capacitor c=315.899a
    C323  (vdd\#24 X50_5)  capacitor c=333.968a
    C524  (Y4\#7 X50_5)  capacitor c=453.051a
    C579  (Y3\#7 X50_5)  capacitor c=297.685a
    C509  (Y3\#9 Y4\#8)  capacitor c=140.533a
    C313  (Y3\#9 vdd\#25)  capacitor c=107.267a
    C519  (Y4\#5 net12)  capacitor c=83.616a
    C280  (vdd\#25 CK\#8)  capacitor c=158.19a
    C377  (Y3\#9 CK\#8)  capacitor c=644.676a
    C409  (CK\#6 net11)  capacitor c=83.616a
    C412  (net12\#2 CK\#6)  capacitor c=83.616a
    C324  (vdd\#25 X49_5)  capacitor c=328.08a
    C413  (CK\#8 X49_5)  capacitor c=453.221a
    C580  (Y3\#9 X49_5)  capacitor c=316.082a
    C473  (RNi\#2310 net5)  capacitor c=83.616a
    C474  (net6\#2 RNi\#2310)  capacitor c=83.616a
    C476  (RNi\#2311 net2)  capacitor c=3.42762e-18
    C477  (net2\#2 RNi\#2311)  capacitor c=3.42859e-18
    C607  (net2 13)  capacitor c=237.088a
    C608  (net2\#2 13)  capacitor c=237.325a
    C110  (vss\#1 net2)  capacitor c=103.983a
    C111  (net2\#2 vss\#1)  capacitor c=73.7811a
    C108  (vss\#1 net1)  capacitor c=77.1879a
    C605  (net1 13)  capacitor c=237.088a
    C606  (net1\#2 13)  capacitor c=237.325a
    C109  (net1\#2 vss\#1)  capacitor c=76.085a
    C614  (net2\#2 net1)  capacitor c=39.8112a
    C126  (D\#4 net1)  capacitor c=83.616a
    C127  (net2\#2 D\#4)  capacitor c=83.616a
    C485  (Y1\#4 Y4\#8)  capacitor c=156.822a
    C487  (Y1\#6 Y4\#8)  capacitor c=298.786a
    C518  (net7\#2 Y4)  capacitor c=83.616a
    C609  (net7\#2 net8)  capacitor c=39.8112a
    C520  (Y4\#2311 net1\#2)  capacitor c=41.34a
    C576  (net1\#2 Y3\#2315)  capacitor c=83.616a
    C537  (Y1\#2 net7)  capacitor c=41.34a
    C556  (Y2\#3 net7)  capacitor c=83.616a
    C557  (net9\#2 Y2\#2)  capacitor c=1.83462e-18
    C558  (Y2\#5 net9\#2)  capacitor c=39.8112a
    C286  (vdd\#33 RNi\#4)  capacitor c=155.241a
    C305  (Y2\#7 vdd\#33)  capacitor c=106.406a
    C448  (Y2\#7 RNi\#4)  capacitor c=660.925a
    C480  (RNi\#4 X41_5)  capacitor c=453.221a
    C332  (vdd\#33 X41_5)  capacitor c=333.024a
    C563  (Y2\#7 X41_5)  capacitor c=316.082a
    C281  (vdd\#34 CK\#1)  capacitor c=155.241a
    C306  (Y2\#9 vdd\#34)  capacitor c=107.267a
    C370  (Y2\#9 CK\#1)  capacitor c=665.355a
    C414  (CK\#1 X40_5)  capacitor c=453.221a
    C333  (vdd\#34 X40_5)  capacitor c=328.08a
    C564  (Y2\#9 X40_5)  capacitor c=316.082a
    C296  (vdd\#35 Y1\#9)  capacitor c=144.16a
    C307  (Y2\#2311 vdd\#35)  capacitor c=111.825a
    C528  (Y2\#2311 Y1\#9)  capacitor c=147.723a
    C334  (vdd\#35 X39_5)  capacitor c=333.968a
    C539  (Y1\#9 X39_5)  capacitor c=356.549a
    C532  (Y1\#2310 Y2\#2311)  capacitor c=615.939a
    C565  (Y2\#2311 X39_5)  capacitor c=316.116a
    C540  (Y1\#2310 X39_5)  capacitor c=112.751a
    C538  (net9\#2 Y1\#2311)  capacitor c=83.616a
    C176  (vdd\#38 SN\#7)  capacitor c=158.794a
    C230  (SN\#7 X36_5)  capacitor c=486.352a
    C299  (Y1\#8 vdd\#38)  capacitor c=86.3337a
    C337  (vdd\#38 X36_5)  capacitor c=331.309a
    C543  (Y1\#8 X36_5)  capacitor c=172.116a
    C481  (RNi\#2318 X36_5)  capacitor c=44.388a
    C287  (RNi\#2318 vdd\#39)  capacitor c=123.912a
    C177  (vdd\#39 SN\#1)  capacitor c=183.136a
    C231  (SN\#1 X35_5)  capacitor c=512.696a
    C482  (RNi\#2318 X35_5)  capacitor c=183.468a
    C338  (vdd\#39 X35_5)  capacitor c=160.254a
    C294  (vdd\#37 Y4\#3)  capacitor c=158.19a
    C297  (Y1\#4 vdd\#36)  capacitor c=111.119a
    C298  (Y1\#6 vdd\#37)  capacitor c=107.649a
    C486  (Y1\#6 Y4\#3)  capacitor c=421.39a
    C336  (vdd\#37 X37_5)  capacitor c=356.74a
    C525  (Y4\#3 X37_5)  capacitor c=453.048a
    C542  (Y1\#6 X37_5)  capacitor c=315.034a
    C308  (vdd\#36 Y2\#4)  capacitor c=158.19a
    C530  (Y1\#4 Y2\#4)  capacitor c=672.671a
    C335  (vdd\#36 X38_5)  capacitor c=333.968a
    C541  (Y1\#4 X38_5)  capacitor c=316.082a
    C566  (Y2\#4 X38_5)  capacitor c=453.202a
    MX53_M0_unmatched  (Y4\#2312 RNi\#2312 vdd\#1 vdd\#1)  pch w=4e-06 \
        l=1e-06 as=0 ad=1e-11 ps=0 pd=1.3e-05 sa=2e-06 sb=2e-06
    MX52_M0_unmatched  (Y4\#2313 D\#2 vdd\#22 vdd\#22)  pch w=4e-06 \
        l=1e-06 as=0 ad=1e-11 ps=0 pd=1.3e-05 sa=2e-06 sb=2e-06
    MX51_M0_unmatched  (Y4\#2315 Y3\#2313 vdd\#23 vdd\#23)  pch w=4e-06 \
        l=1e-06 as=0 ad=1e-11 ps=0 pd=1.3e-05 sa=2e-06 sb=2e-06
    MX50_M0_unmatched  (Y3\#7 Y4\#7 vdd\#24 vdd\#24)  pch w=4e-06 l=1e-06 \
        as=0 ad=1e-11 ps=0 pd=1.3e-05 sa=2e-06 sb=2e-06
    MX45_M0_unmatched  (QN\#2310 Q\#2310 vdd\#29 vdd\#29)  pch w=4e-06 \
        l=1e-06 as=0 ad=1e-11 ps=0 pd=1.3e-05 sa=2e-06 sb=2e-06
    MX43_M0_unmatched  (Q\#7 SN\#2312 vdd\#31 vdd\#31)  pch w=4e-06 \
        l=1e-06 as=0 ad=1e-11 ps=0 pd=1.3e-05 sa=2e-06 sb=2e-06
    MX44_M0_unmatched  (Q\#5 QN\#5 vdd\#30 vdd\#30)  pch w=4e-06 l=1e-06 \
        as=0 ad=1e-11 ps=0 pd=1.3e-05 sa=2e-06 sb=2e-06
    MX42_M0_unmatched  (Q\#9 Y2\#2315 vdd\#32 vdd\#32)  pch w=4e-06 \
        l=1e-06 as=0 ad=1e-11 ps=0 pd=1.3e-05 sa=2e-06 sb=2e-06
    MX46_M0_unmatched  (QN\#8 RNi\#8 vdd\#28 vdd\#28)  pch w=4e-06 l=1e-06 \
        as=0 ad=1e-11 ps=0 pd=1.3e-05 sa=2e-06 sb=2e-06
    MX47_M0_unmatched  (QN\#7 Y3\#2 vdd\#27 vdd\#27)  pch w=4e-06 l=1e-06 \
        as=0 ad=1e-11 ps=0 pd=1.3e-05 sa=2e-06 sb=2e-06
    MX33_M0_unmatched  (net13\#4 RN\#2 vdd\#21 vdd\#21)  pch w=4e-06 \
        l=1e-06 as=0 ad=1e-11 ps=0 pd=1.3e-05 sa=2e-06 sb=2e-06
    MX34_M0_unmatched  (RNi\#2317 net13\#5 vdd\#40 vdd\#40)  pch w=4e-06 \
        l=1e-06 as=0 ad=1e-11 ps=0 pd=1.3e-05 sa=2e-06 sb=2e-06
    MX48_M0_unmatched  (Y3\#2311 Y2\#20 vdd\#26 vdd\#26)  pch w=4e-06 \
        l=1e-06 as=0 ad=1e-11 ps=0 pd=1.3e-05 sa=2e-06 sb=2e-06
    MX49_M0_unmatched  (Y3\#9 CK\#8 vdd\#25 vdd\#25)  pch w=4e-06 l=1e-06 \
        as=0 ad=1e-11 ps=0 pd=1.3e-05 sa=2e-06 sb=2e-06
    MX41_M0_unmatched  (Y2\#7 RNi\#4 vdd\#33 vdd\#33)  pch w=4e-06 l=1e-06 \
        as=0 ad=1e-11 ps=0 pd=1.3e-05 sa=2e-06 sb=2e-06
    MX40_M0_unmatched  (Y2\#9 CK\#1 vdd\#34 vdd\#34)  pch w=4e-06 l=1e-06 \
        as=0 ad=1e-11 ps=0 pd=1.3e-05 sa=2e-06 sb=2e-06
    MX39_M0_unmatched  (Y2\#2311 Y1\#9 vdd\#35 vdd\#35)  pch w=4e-06 \
        l=1e-06 as=0 ad=1e-11 ps=0 pd=1.3e-05 sa=2e-06 sb=2e-06
    MX36_M0_unmatched  (Y1\#8 SN\#7 vdd\#38 vdd\#38)  pch w=4e-06 l=1e-06 \
        as=0 ad=1e-11 ps=0 pd=1.3e-05 sa=2e-06 sb=2e-06
    MX35_M0_unmatched  (RNi\#2318 SN\#1 vdd\#39 vdd\#39)  pch w=4e-06 \
        l=1e-06 as=0 ad=1e-11 ps=0 pd=1.3e-05 sa=2e-06 sb=2e-06
    MX37_M0_unmatched  (Y1\#6 Y4\#3 vdd\#37 vdd\#37)  pch w=4e-06 l=1e-06 \
        as=0 ad=1e-11 ps=0 pd=1.3e-05 sa=2e-06 sb=2e-06
    MX38_M0_unmatched  (Y1\#4 Y2\#4 vdd\#36 vdd\#36)  pch w=4e-06 l=1e-06 \
        as=0 ad=1e-11 ps=0 pd=1.3e-05 sa=2e-06 sb=2e-06
    Rc79  (vdd\#3 vdd\#4)  resistor r=189.6m
    Rd35  (RNi\#5 RNi\#2311)  resistor r=178.5325
    Rd45  (Y4\#2 Y4\#8)  resistor r=89.064
    Rd21  (vss\#4 vss\#6)  resistor r=576.6m
    Rc114  (RNi\#3 RNi\#5)  resistor r=166.6304
    Rc115  (RNi\#3 RNi\#2311)  resistor r=2.9246
    Rc65  (vss\#2 vss\#4)  resistor r=576.6m
    Rc66  (vss vss\#6)  resistor r=200.1m
    Rc9  (CK\#2 CK\#5)  resistor r=493.5764
    Rc10  (CK\#5 CK)  resistor r=9.2404
    Rc13  (CK\#2 CK)  resistor r=105.2963
    Rs1  (13 vss)  resistor r=50
    Rc77  (D\#2 D\#3)  resistor r=1044.8411
    Rc99  (D\#3 D)  resistor r=85.564
    Rd67  (Q\#2311 Q\#2310)  resistor r=201.111
    Rc126  (Q\#2311 Q\#2312)  resistor r=3744.2583
    Rc127  (Q Q\#3)  resistor r=553.5043
    Rd1  (SN\#6 SN\#7)  resistor r=2844.8411
    Rc124  (SN\#6 SN\#9)  resistor r=1545.1519
    Rc51  (QN\#4 QN\#5)  resistor r=3908.8093
    Rc52  (QN\#4 QN\#3)  resistor r=1723.2665
    Rc57  (QN\#3 QN\#6)  resistor r=10.1
    Rc100  (vdd\#1 vdd\#3)  resistor r=2.7467
    Rc41  (CK\#1 CK\#2)  resistor r=3444.8411
    Rc6  (vss\#4 vss\#2311)  resistor r=5.0974
    Rd23  (vss\#4 vss\#2312)  resistor r=6.7931
    Rc68  (vss\#2312 vss\#6)  resistor r=22.1536
    Rd24  (vss\#6 vss\#2313)  resistor r=5.0974
    Rc123  (SN\#6 SN\#8)  resistor r=1036.0317
    Rc7  (net8 net8\#2)  resistor r=10.1
    Rc44  (CK\#2 CK\#3)  resistor r=436.0318
    Rc93  (RNi\#5 RNi\#6)  resistor r=1636.0317
    Rc17  (net10 net10\#2)  resistor r=10.1
    Rc15  (RNi\#3 RNi\#2318)  resistor r=2.9889
    Rd43  (RNi\#3 RNi\#2317)  resistor r=3.3227
    Rc18  (RNi\#2318 RNi\#2317)  resistor r=50.1091
    Rd11  (RNi\#9 RNi\#2311)  resistor r=85.464
    Rd30  (D\#3 D\#4)  resistor r=2836.0317
    Rd34  (RNi\#2313 RNi\#2312)  resistor r=2244.8411
    Rc78  (vdd\#1 vdd\#22)  resistor r=108.4015
    Rd52  (vdd\#22 vdd\#3)  resistor r=2.6763
    Rc94  (RNi\#2311 RNi\#2313)  resistor r=87.364
    Rc21  (Y4\#2312 Y4\#2313)  resistor r=38.95
    Rc24  (Y4\#2312 Y4\#2316)  resistor r=3.116
    Rd40  (Y4\#2313 Y4\#2316)  resistor r=2.8852
    Rd37  (Y4\#8 Y4\#2316)  resistor r=615.5m
    Rd38  (vss\#1 vss\#2)  resistor r=5.5378
    Rc46  (RNi\#2313 RNi\#2314)  resistor r=1636.0317
    Rc95  (RNi\#9 RNi\#2310)  resistor r=1636.0317
    Rd13  (RNi\#8 RNi\#9)  resistor r=2244.8411
    Rd8  (RNi\#3 RNi)  resistor r=840.853
    Rd36  (RNi RNi\#2)  resistor r=10.1
    Rd44  (Y4\#2 Y4\#3)  resistor r=1044.8411
    Rd39  (Y4\#2316 Y4\#2315)  resistor r=2.5
    Rc20  (Y4\#2311 Y4\#2316)  resistor r=2976.8799
    Rd42  (Y4\#8 Y4\#2311)  resistor r=2831.2012
    Rc22  (Y4\#2 Y4)  resistor r=2836.0317
    Rc35  (Y1 Y1\#2)  resistor r=10.1
    Rc88  (Y2\#2315 Y2\#6)  resistor r=701.957
    Rc89  (Y2\#2314 Y2\#2313)  resistor r=2236.0317
    Rc25  (net3 net3\#2)  resistor r=10.1
    Rd63  (Y2\#2315 Y2\#2314)  resistor r=1644.8412
    Rd61  (Y2\#2314 Y2\#2317)  resistor r=92.164
    Rc58  (QN\#7 QN\#2311)  resistor r=3.116
    Rc27  (QN\#3 QN\#2311)  resistor r=121570.4219
    Rd59  (Y2\#3 Y2\#4)  resistor r=3908.8093
    Rd66  (SN\#6 SN)  resistor r=90.8913
    Rc28  (Y1\#3 Y1)  resistor r=1735.853
    Rd12  (RNi\#5 RNi\#4)  resistor r=2244.8411
    Rd50  (Y2\#3 Y2\#2)  resistor r=1723.2665
    Rd64  (Y2\#2 Y2\#5)  resistor r=10.1
    Rc125  (SN\#9 SN)  resistor r=7.2318
    Rd2  (SN\#2311 SN\#9)  resistor r=80.464
    Rc116  (SN\#2311 SN\#2310)  resistor r=1036.0317
    Rd3  (SN\#2311 SN\#2312)  resistor r=2844.8411
    Rd54  (Y3\#6 Y3\#5)  resistor r=1745.953
    Rd6  (Y3 Y3\#2311)  resistor r=4.6937
    Rd55  (Y3\#2314 Y3\#2313)  resistor r=219.2584
    Rc73  (Y3\#6 Y3\#2314)  resistor r=1521.2155
    Rc59  (Y3\#2314 Y3\#2315)  resistor r=3688.636
    Rd51  (vdd\#3 vdd\#23)  resistor r=2.5488
    Rc70  (SN\#2 SN\#4)  resistor r=1636.0317
    Rc5  (net14 net14\#2)  resistor r=10.1
    Rd5  (SN\#1 SN\#2)  resistor r=1336.0317
    Rd65  (SN\#2 SN)  resistor r=85.564
    Rc118  (Q\#4 Q)  resistor r=1151.5636
    Rc56  (QN\#3 QN)  resistor r=543.3479
    Rc63  (vss vss\#8)  resistor r=5.1322
    Rc67  (vss vss\#2314)  resistor r=6.1438
    Rd33  (vdd vdd\#21)  resistor r=2.7572
    Rd58  (vdd vdd\#20)  resistor r=66.34m
    Rc85  (vdd\#2315 vdd\#2316)  resistor r=189.6m
    Rc69  (Y3\#6 Y3\#7)  resistor r=73.2063
    Rc74  (Y3\#6 Y3\#2310)  resistor r=5.8565
    Rc117  (Q\#4 Q\#2311)  resistor r=1642.5249
    Rc26  (QN\#2311 QN\#2310)  resistor r=2.5
    Rd46  (vdd\#9 vdd\#29)  resistor r=2.5488
    Rc82  (vdd\#9 vdd\#2310)  resistor r=189.6m
    Rc104  (vdd\#2310 vdd\#31)  resistor r=5.1621
    Rc83  (vdd\#31 vdd\#2312)  resistor r=5.1621
    Rd48  (vdd\#2310 vdd\#2312)  resistor r=130.8m
    Rd47  (vdd\#2310 vdd\#30)  resistor r=2.5488
    Rc128  (Q\#4 Q\#5)  resistor r=73.2063
    Rc120  (Q\#5 Q\#8)  resistor r=2.7955
    Rc122  (Q\#4 Q\#8)  resistor r=5.8565
    Rc129  (Q\#8 Q\#7)  resistor r=2.5
    Rc121  (Q\#8 Q\#9)  resistor r=2.7
    Rd68  (vdd\#2312 vdd\#32)  resistor r=2.5488
    Rc105  (vdd\#2312 vdd\#2313)  resistor r=106.2m
    Rc54  (QN QN\#2311)  resistor r=1157.0509
    Rc55  (QN\#8 QN\#2311)  resistor r=2.8852
    Rc119  (Q\#4 Q\#3)  resistor r=123274.4219
    Rc16  (net9 net9\#2)  resistor r=10.1
    Rd20  (vss\#2310 vss\#4)  resistor r=22.1536
    Rc29  (net4 net4\#2)  resistor r=10.1
    Rd22  (vss\#2 vss\#2310)  resistor r=6.7931
    Rc39  (net5 net5\#2)  resistor r=10.1
    Rc40  (net6 net6\#2)  resistor r=10.1
    Rc72  (Y3\#2 Y3\#3)  resistor r=3908.8093
    Rc90  (Y2\#2319 Y2\#2317)  resistor r=80.464
    Rc47  (net11 net11\#2)  resistor r=10.1
    Rc64  (vss\#2 vss\#9)  resistor r=5.0974
    Rc50  (net12 net12\#2)  resistor r=10.1
    Rc42  (CK\#7 CK\#5)  resistor r=80.464
    Rc111  (Y2\#2319 Y2\#2318)  resistor r=2236.0317
    Rd49  (Y2\#2319 Y2\#20)  resistor r=1644.8412
    Rd25  (vss\#6 vss\#2314)  resistor r=30.9033
    Rc8  (net7 net7\#2)  resistor r=10.1
    Rc103  (vdd\#28 vdd\#9)  resistor r=5.1621
    Rd29  (vdd\#7 vdd\#9)  resistor r=130.8m
    Rc81  (vdd\#7 vdd\#28)  resistor r=5.1621
    Rc53  (QN\#7 QN\#8)  resistor r=38.95
    Rd28  (vdd\#7 vdd\#27)  resistor r=2.5488
    Rc102  (vdd\#6 vdd\#7)  resistor r=106.2m
    Rd26  (Y3\#2 Y3)  resistor r=706.957
    Rd4  (Y3 Y3\#2310)  resistor r=375.5m
    Rd56  (Y3\#7 Y3\#2310)  resistor r=2.7955
    Rd31  (RN\#3 RN)  resistor r=85.564
    Rc98  (RN\#3 RN\#4)  resistor r=1036.0317
    Rc96  (net13\#6 net13\#7)  resistor r=1636.0317
    Rd17  (RN\#2 RN\#3)  resistor r=1936.0317
    Rd18  (net13\#3 net13\#4)  resistor r=10.9636
    Rc76  (net13 net13\#3)  resistor r=20.0823
    Rd32  (net13\#6 net13)  resistor r=80.464
    Rd19  (net13\#5 net13\#6)  resistor r=1336.0317
    Rc97  (net13 net13\#4)  resistor r=10.5113
    Rc109  (vdd\#20 vdd\#40)  resistor r=2.7224
    Rd70  (vdd\#2313 vdd\#2315)  resistor r=130.8m
    Rc30  (Y1\#3 Y1\#2310)  resistor r=1642.5249
    Rd27  (vdd\#6 vdd\#26)  resistor r=2.5488
    Rc75  (Y3\#2310 Y3\#2311)  resistor r=5.7769
    Rd53  (vdd\#4 vdd\#24)  resistor r=2.5488
    Rd41  (Y4\#6 Y4\#7)  resistor r=1044.8411
    Rc71  (Y3\#2310 Y3\#9)  resistor r=2.5
    Rd10  (vdd\#4 vdd\#6)  resistor r=130.8m
    Rc101  (vdd\#4 vdd\#25)  resistor r=5.1621
    Rc80  (vdd\#25 vdd\#6)  resistor r=5.1621
    Rc19  (Y4\#6 Y4\#8)  resistor r=85.464
    Rc23  (Y4\#6 Y4\#5)  resistor r=2836.0317
    Rc43  (CK\#7 CK\#8)  resistor r=3444.8411
    Rc45  (CK\#7 CK\#6)  resistor r=436.0318
    Rc62  (net2 net2\#2)  resistor r=10.1
    Rc60  (net1 net1\#2)  resistor r=10.1
    Rd69  (vdd\#2313 vdd\#33)  resistor r=2.5488
    Rc84  (vdd\#2313 vdd\#34)  resistor r=5.1621
    Rc106  (vdd\#34 vdd\#2315)  resistor r=5.1621
    Rd60  (vdd\#2315 vdd\#35)  resistor r=2.5488
    Rc112  (Y2\#6 Y2\#7)  resistor r=72.1937
    Rc91  (Y2\#6 Y2\#2310)  resistor r=5.7755
    Rc110  (Y2\#2 Y2)  resistor r=1740.853
    Rd57  (vdd\#39 vdd\#20)  resistor r=3.7878
    Rc87  (vdd\#2318 vdd\#20)  resistor r=119.8m
    Rc33  (Y1\#3 Y1\#7)  resistor r=5.8565
    Rc36  (Y1\#3 Y1\#4)  resistor r=73.2063
    Rc113  (Y2\#2310 Y2\#9)  resistor r=2.5
    Rd62  (Y2\#7 Y2\#2310)  resistor r=2.7969
    Rd9  (Y2\#2310 Y2\#2311)  resistor r=4.8053
    Rd7  (Y2 Y2\#2310)  resistor r=456.5m
    Rc92  (Y2 Y2\#2311)  resistor r=5.7062
    Rc31  (Y1\#2310 Y1\#9)  resistor r=201.111
    Rc32  (Y1\#2310 Y1\#2311)  resistor r=3744.2583
    Rd16  (vdd\#2318 vdd\#38)  resistor r=2.5488
    Rc38  (Y1\#7 Y1\#8)  resistor r=2.7
    Rc108  (vdd\#2318 vdd\#39)  resistor r=9.9848
    Rd14  (vdd\#2316 vdd\#2318)  resistor r=130.8m
    Rc86  (vdd\#37 vdd\#2318)  resistor r=5.1621
    Rc107  (vdd\#2316 vdd\#37)  resistor r=5.1621
    Rd15  (vdd\#2316 vdd\#36)  resistor r=2.5488
    Rc34  (Y1\#4 Y1\#7)  resistor r=2.7955
    Rc37  (Y1\#7 Y1\#6)  resistor r=2.5
    MX57_M0_unmatched  (net8\#2 SN\#8 vss\#2313 vss\#2313)  nch w=2e-06 \
        l=1e-06 as=0 ad=5e-12 ps=0 pd=9e-06 sa=2e-06 sb=2e-06
    MX62_M0_unmatched  (net10 RNi\#6 vss\#2312 vss\#2312)  nch w=2e-06 \
        l=1e-06 as=0 ad=5e-12 ps=0 pd=9e-06 sa=2e-06 sb=2e-06
    MX63_M0_unmatched  (net3\#2 Y2\#2313 vss\#2311 vss\#2311)  nch w=2e-06 \
        l=1e-06 as=0 ad=5e-12 ps=0 pd=9e-06 sa=2e-06 sb=2e-06
    MX56_M0_unmatched  (RNi\#2 SN\#4 net14 net14)  nch w=2e-06 l=1e-06 as=0 \
        ad=5e-12 ps=0 pd=9e-06 sa=2e-06 sb=2e-06
    MX64_M0_unmatched  (net4\#2 SN\#2310 net3 net3)  nch w=2e-06 l=1e-06 \
        as=0 ad=5e-12 ps=0 pd=9e-06 sa=2e-06 sb=2e-06
    MX61_M0_unmatched  (net9 CK\#3 net10\#2 net10\#2)  nch w=2e-06 l=1e-06 \
        as=0 ad=5e-12 ps=0 pd=9e-06 sa=2e-06 sb=2e-06
    MX65_M0_unmatched  (Q\#3 QN\#4 net4 net4)  nch w=2e-06 l=1e-06 as=0 \
        ad=5e-12 ps=0 pd=9e-06 sa=2e-06 sb=2e-06
    MX66_M0_unmatched  (QN\#6 Q\#2312 net5\#2 net5\#2)  nch w=2e-06 l=1e-06 \
        as=0 ad=5e-12 ps=0 pd=9e-06 sa=2e-06 sb=2e-06
    MX55_M0_unmatched  (net14\#2 net13\#7 vss\#2314 vss\#2314)  nch \
        w=2e-06 l=1e-06 as=0 ad=5e-12 ps=0 pd=9e-06 sa=2e-06 sb=2e-06
    MX71_M0_unmatched  (Y3\#5 Y4\#5 net12 net12)  nch w=2e-06 l=1e-06 as=0 \
        ad=5e-12 ps=0 pd=9e-06 sa=2e-06 sb=2e-06
    MX74_M0_unmatched  (net2 RNi\#2314 vss\#1 vss\#1)  nch w=2e-06 l=1e-06 \
        as=0 ad=5e-12 ps=0 pd=9e-06 sa=2e-06 sb=2e-06
    MX68_M0_unmatched  (net6 Y3\#3 vss\#2310 vss\#2310)  nch w=2e-06 \
        l=1e-06 as=0 ad=5e-12 ps=0 pd=9e-06 sa=2e-06 sb=2e-06
    MX69_M0_unmatched  (net11\#2 Y2\#2318 vss\#9 vss\#9)  nch w=2e-06 \
        l=1e-06 as=0 ad=5e-12 ps=0 pd=9e-06 sa=2e-06 sb=2e-06
    MX54_M0_unmatched  (net13\#3 RN\#4 vss\#8 vss\#8)  nch w=2e-06 l=1e-06 \
        as=0 ad=5e-12 ps=0 pd=9e-06 sa=2e-06 sb=2e-06
    MX70_M0_unmatched  (net12\#2 CK\#6 net11 net11)  nch w=2e-06 l=1e-06 \
        as=0 ad=5e-12 ps=0 pd=9e-06 sa=2e-06 sb=2e-06
    MX67_M0_unmatched  (net5 RNi\#2310 net6\#2 net6\#2)  nch w=2e-06 l=1e-06 \
        as=0 ad=5e-12 ps=0 pd=9e-06 sa=2e-06 sb=2e-06
    MX73_M0_unmatched  (net1 D\#4 net2\#2 net2\#2)  nch w=2e-06 l=1e-06 as=0 \
        ad=5e-12 ps=0 pd=9e-06 sa=2e-06 sb=2e-06
    MX58_M0_unmatched  (net7\#2 Y4 net8 net8)  nch w=2e-06 l=1e-06 as=0 \
        ad=5e-12 ps=0 pd=9e-06 sa=2e-06 sb=2e-06
    MX72_M0_unmatched  (Y4\#2311 Y3\#2315 net1\#2 net1\#2)  nch w=2e-06 \
        l=1e-06 as=0 ad=5e-12 ps=0 pd=9e-06 sa=2e-06 sb=2e-06
    MX59_M0_unmatched  (Y1\#2 Y2\#3 net7 net7)  nch w=2e-06 l=1e-06 as=0 \
        ad=5e-12 ps=0 pd=9e-06 sa=2e-06 sb=2e-06
    MX60_M0_unmatched  (Y2\#5 Y1\#2311 net9\#2 net9\#2)  nch w=2e-06 l=1e-06 \
        as=0 ad=5e-12 ps=0 pd=9e-06 sa=2e-06 sb=2e-06
ends DFFSRX1
