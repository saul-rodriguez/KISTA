// MX4X1
simulator lang=spectre insensitive=yes
global vss vdd
subckt MX4X1 D Y B A S0 C S1
    C248  (vdd\#6 X44_5)  capacitor c=46.1985a
    C28  (vdd\#1 Y\#2)  capacitor c=140.489a
    C29  (Y\#2 Yn\#22)  capacitor c=325.058a
    C36  (Y\#2 10)  capacitor c=1.33547e-15
    C83  (vdd\#4 vss)  capacitor c=82.453a
    C95  (S1\#4 vss)  capacitor c=3.06075e-18
    C108  (Yn\#22 vss)  capacitor c=2.97089e-18
    C125  (vss\#3 10)  capacitor c=81.0391f
    C222  (vdd\#4 S1\#4)  capacitor c=1.30209e-15
    C228  (vdd\#1 Yn\#22)  capacitor c=233.92a
    C234  (vdd\#4 10)  capacitor c=78.6397f
    C276  (Yn\#2319 S1)  capacitor c=4.59604e-15
    C278  (Yn\#2319 S1\#4)  capacitor c=8.09743e-19
    C286  (10 S1)  capacitor c=17.6862f
    C293  (S1\#4 10)  capacitor c=8.24401e-15
    C351  (Yn\#22 10)  capacitor c=1.8281e-15
    C353  (Yn\#2319 10)  capacitor c=71.109f
    C1  (D\#4 vss)  capacitor c=11.831a
    C12  (D\#4 10)  capacitor c=4.18077e-15
    C2  (D\#2 vss)  capacitor c=8.13935e-18
    C13  (D\#2 10)  capacitor c=599.327a
    C3  (D\#3 vss)  capacitor c=10.845a
    C14  (D\#3 10)  capacitor c=4.41749e-15
    C4  (vss\#3 D)  capacitor c=224.92a
    C11  (10 D)  capacitor c=2.87351e-15
    C5  (D\#2 S0\#2312)  capacitor c=10.1661a
    C200  (S0\#2312 10)  capacitor c=2.81712e-15
    C6  (S0\#2311 D\#4)  capacitor c=584.344a
    C77  (S0\#2311 vss)  capacitor c=15.8567a
    C203  (S0\#2311 10)  capacitor c=7.62842e-15
    C7  (vdd\#2 D\#4)  capacitor c=13.9788a
    C8  (S0n\#2312 D\#4)  capacitor c=605.364a
    C100  (S0n\#2312 vss)  capacitor c=6.13879e-18
    C176  (S0\#2311 S0n\#2312)  capacitor c=385.081a
    C325  (S0n\#2312 10)  capacitor c=6.38721e-15
    C9  (Yn\#2317 D\#3)  capacitor c=627.566a
    C191  (Yn\#2317 S0\#2311)  capacitor c=1.11178e-15
    C78  (S0\#9 vss)  capacitor c=5.10525e-18
    C177  (S0\#9 S0n\#2312)  capacitor c=39.1184a
    C204  (S0\#9 10)  capacitor c=8.0748e-15
    C10  (S1n\#5 D\#4)  capacitor c=12.6703a
    C120  (S1n\#5 vss)  capacitor c=9.81953e-18
    C233  (vdd\#2 S1n\#5)  capacitor c=1.24583e-15
    C381  (S1n\#5 10)  capacitor c=5.21905e-15
    C15  (D\#4 net13)  capacitor c=210.575a
    C130  (net13 vss)  capacitor c=4.59623e-18
    C339  (S0n\#2312 net13)  capacitor c=209.929a
    C403  (net13 10)  capacitor c=277.702a
    C16  (net15\#2 D\#4)  capacitor c=256.859a
    C131  (net15\#2 vss)  capacitor c=2.92257e-18
    C246  (vdd\#2 net15\#2)  capacitor c=200.486a
    C407  (net15\#2 10)  capacitor c=882.067a
    C434  (net15\#2 net13)  capacitor c=84.6238a
    C24  (D\#4 X43_5)  capacitor c=532.154a
    C435  (X43_5 net13)  capacitor c=163.003a
    C439  (net15\#2 X43_5)  capacitor c=152.718a
    C245  (vdd\#1 net15)  capacitor c=218.954a
    C342  (S0n\#2312 net15)  capacitor c=28.6724a
    C362  (Yn\#22 net15)  capacitor c=3.84387e-18
    C406  (net15 10)  capacitor c=927.348a
    C17  (net20 D)  capacitor c=73.6976a
    C18  (D\#2 net20)  capacitor c=84.1028a
    C20  (D\#3 net20)  capacitor c=579.428a
    C23  (D\#3 net19\#2)  capacitor c=1.45336e-18
    C21  (net19\#2 D)  capacitor c=80.8514a
    C19  (net20\#2 D)  capacitor c=66.5382a
    C22  (net19\#2 D\#2)  capacitor c=118.603a
    C143  (vss\#3 net20)  capacitor c=13.9835a
    C214  (S0\#2312 net20)  capacitor c=11.6294a
    C371  (Yn\#2317 net20)  capacitor c=45.2515a
    C374  (Yn\#2317 net19\#2)  capacitor c=4.83751e-18
    C417  (net20 10)  capacitor c=737.952a
    C418  (net20\#2 10)  capacitor c=1.9318e-15
    C421  (net19\#2 10)  capacitor c=665.556a
    C443  (net19\#2 net20)  capacitor c=50.7743a
    C142  (net20\#4 vss)  capacitor c=3.66376e-18
    C304  (net20\#4 S1)  capacitor c=56.629a
    C419  (net20\#4 10)  capacitor c=711.844a
    C25  (vss Y)  capacitor c=15.5932a
    C32  (Yn\#2317 Y)  capacitor c=438.612a
    C35  (10 Y)  capacitor c=2.76622e-15
    C27  (Y\#1 S0\#2312)  capacitor c=7.43747e-18
    C33  (Yn\#2317 Y\#1)  capacitor c=28.0734a
    C37  (Y\#1 10)  capacitor c=1.39536e-15
    C34  (Yn\#23 Y)  capacitor c=28.3925a
    C117  (Yn\#23 vss)  capacitor c=8.82352e-19
    C354  (Yn\#23 10)  capacitor c=351.766a
    C375  (Yn\#22 X45_5)  capacitor c=464.956a
    C30  (Y\#1 Yn\#24)  capacitor c=238.723a
    C38  (Y\#2 X45_5)  capacitor c=406.987a
    C247  (vdd\#1 X45_5)  capacitor c=219.85a
    C31  (Yn\#21 Y\#2)  capacitor c=38.2566a
    C224  (vdd\#1 S0n\#2313)  capacitor c=52.0298a
    C97  (S0n\#2313 vss)  capacitor c=10.9141a
    C110  (Yn\#21 vss)  capacitor c=9.91545e-18
    C309  (Yn\#21 S0n\#2313)  capacitor c=172.197a
    C310  (Yn\#21 S0n\#2312)  capacitor c=108.602a
    C321  (S0n\#2313 10)  capacitor c=1.08611e-15
    C341  (S0n\#2313 net15)  capacitor c=219.374a
    C352  (Yn\#24 10)  capacitor c=1.90331e-15
    C360  (Yn\#21 net13)  capacitor c=4.01613e-18
    C363  (Yn\#21 net15)  capacitor c=82.5972a
    C101  (S0n\#2311 vss)  capacitor c=13.0426a
    C178  (S0n\#2311 S0\#9)  capacitor c=2.21052e-15
    C326  (S0n\#2311 10)  capacitor c=11.4354f
    C346  (S0n\#2313 X44_5)  capacitor c=514.19a
    C376  (Yn\#21 X44_5)  capacitor c=180.784a
    C438  (X44_5 net15)  capacitor c=152.718a
    C26  (vss\#1 Y\#1)  capacitor c=107.779a
    C81  (vss\#1 S0\#2312)  capacitor c=20.5237a
    C109  (vss\#1 Yn\#24)  capacitor c=188.956a
    C372  (Yn\#24 net19)  capacitor c=3.36761e-18
    C144  (vss\#1 net19)  capacitor c=1.14e-16
    C145  (net19\#2 vss\#1)  capacitor c=104.292a
    C215  (S0\#2312 net19)  capacitor c=160.198a
    C420  (net19 10)  capacitor c=606.698a
    C141  (net20\#2 vss\#6)  capacitor c=68.8998a
    C39  (B\#4 vss)  capacitor c=13.0548a
    C44  (vdd\#4 B\#4)  capacitor c=11.2689a
    C47  (S1\#4 B\#4)  capacitor c=39.8003a
    C55  (B\#4 10)  capacitor c=4.20614e-15
    C40  (B\#2 vss)  capacitor c=20.5042a
    C56  (B\#2 10)  capacitor c=634.372a
    C41  (B\#3 vss)  capacitor c=4.29948e-18
    C45  (B\#3 S1)  capacitor c=587.176a
    C48  (S1\#4 B\#3)  capacitor c=2.71246e-19
    C51  (Yn\#2319 B\#3)  capacitor c=598.015a
    C57  (B\#3 10)  capacitor c=4.31995e-15
    C42  (vss\#3 B)  capacitor c=193.946a
    C54  (10 B)  capacitor c=2.62518e-15
    C43  (S0\#8 B\#4)  capacitor c=584.348a
    C79  (S0\#8 vss)  capacitor c=4.18036e-18
    C170  (S0\#8 S1)  capacitor c=1.13387e-15
    C174  (S1\#4 S0\#8)  capacitor c=3.78237e-19
    C179  (S0\#8 S0n\#2311)  capacitor c=35.8418a
    C193  (Yn\#2319 S0\#8)  capacitor c=2.25873e-15
    C205  (S0\#8 10)  capacitor c=9.32429e-15
    C46  (S1\#2 B\#3)  capacitor c=3.43522e-18
    C173  (S1\#2 S0\#8)  capacitor c=6.63364e-18
    C277  (Yn\#2319 S1\#2)  capacitor c=17.8213a
    C292  (S1\#2 10)  capacitor c=84.2546a
    C49  (B\#4 S0n\#9)  capacitor c=12.79a
    C98  (S0n\#9 vss)  capacitor c=15.0929a
    C322  (S0n\#9 10)  capacitor c=1.32149e-15
    C50  (S0n\#8 B\#4)  capacitor c=607.828a
    C102  (S0n\#8 vss)  capacitor c=17.2282a
    C180  (S0\#8 S0n\#8)  capacitor c=667.311a
    C274  (S1\#4 S0n\#8)  capacitor c=601.826a
    C327  (S0n\#8 10)  capacitor c=8.45233e-15
    C52  (S1n\#6 B)  capacitor c=352.685a
    C53  (B\#3 S1n\#6)  capacitor c=1.27059e-18
    C123  (vss\#3 S1n\#6)  capacitor c=1.56187e-15
    C382  (S1n\#6 10)  capacitor c=7.41936e-15
    C58  (B\#4 net11)  capacitor c=210.188a
    C333  (S0n\#9 net11)  capacitor c=4.47784e-18
    C334  (S0n\#8 net11)  capacitor c=208.435a
    C396  (net11 10)  capacitor c=248.813a
    C59  (net12\#2 B\#4)  capacitor c=312.65a
    C240  (vdd\#4 net12\#2)  capacitor c=179.011a
    C297  (S1\#4 net12\#2)  capacitor c=195.318a
    C400  (net12\#2 10)  capacitor c=644.004a
    C425  (net12\#2 net11)  capacitor c=84.6238a
    C67  (B\#4 X37_5)  capacitor c=523.646a
    C251  (vdd\#4 X37_5)  capacitor c=33.7491a
    C426  (X37_5 net11)  capacitor c=163.003a
    C430  (net12\#2 X37_5)  capacitor c=158.892a
    C128  (net12 vss)  capacitor c=1.25824e-18
    C239  (vdd\#4 net12)  capacitor c=160.194a
    C336  (S0n\#9 net12)  capacitor c=278.481a
    C337  (S0n\#8 net12)  capacitor c=22.66a
    C399  (net12 10)  capacitor c=667.828a
    C60  (net23 B)  capacitor c=77.5462a
    C61  (B\#2 net23)  capacitor c=83.9318a
    C63  (B\#3 net23)  capacitor c=611.135a
    C66  (B\#3 net22\#2)  capacitor c=1.45336e-18
    C64  (net22\#2 B)  capacitor c=80.8514a
    C62  (net23\#2 B)  capacitor c=56.8212a
    C65  (net22\#2 B\#2)  capacitor c=123.991a
    C134  (net23 vss)  capacitor c=11.4043a
    C138  (vss\#3 net22\#2)  capacitor c=101.269a
    C298  (net23\#2 S1)  capacitor c=286.85a
    C299  (S1\#2 net23\#2)  capacitor c=1.67787e-18
    C300  (net22\#2 S1)  capacitor c=15.669a
    C389  (net23\#2 S1n\#6)  capacitor c=173.73a
    C391  (net22\#2 S1n\#6)  capacitor c=117.201a
    C410  (net23 10)  capacitor c=701.87a
    C411  (net23\#2 10)  capacitor c=2.31517e-15
    C414  (net22\#2 10)  capacitor c=642.883a
    C441  (net22\#2 net23)  capacitor c=50.7743a
    C137  (vss\#3 net22)  capacitor c=114.428a
    C413  (net22 10)  capacitor c=604.258a
    C68  (A\#3 vss)  capacitor c=2.25141e-18
    C149  (vdd\#4 A\#3)  capacitor c=17.1702a
    C154  (A\#3 10)  capacitor c=3.90089e-15
    C69  (A\#4 vss)  capacitor c=11.4251a
    C155  (A\#4 10)  capacitor c=561.313a
    C70  (A\#2 vss)  capacitor c=8.67193e-18
    C152  (Yn\#2319 A\#2)  capacitor c=625.27a
    C156  (A\#2 10)  capacitor c=4.2008e-15
    C71  (vss\#3 A)  capacitor c=235.472a
    C153  (10 A)  capacitor c=2.91212e-15
    C161  (net23\#2 A)  capacitor c=66.6915a
    C164  (A\#2 net23\#4)  capacitor c=579.035a
    C136  (vss\#3 net23\#4)  capacitor c=13.4019a
    C162  (net23\#4 A)  capacitor c=75.042a
    C159  (net24 A)  capacitor c=82.3047a
    C133  (vss\#3 net24)  capacitor c=177.432a
    C160  (A\#4 net24)  capacitor c=118.603a
    C163  (net23\#4 A\#4)  capacitor c=84.1366a
    C365  (Yn\#2319 net24)  capacitor c=2.79684e-18
    C367  (Yn\#2319 net23\#4)  capacitor c=42.8246a
    C408  (net24 10)  capacitor c=665.464a
    C412  (net23\#4 10)  capacitor c=738.16a
    C440  (net23\#4 net24)  capacitor c=50.7743a
    C132  (net24\#2 vss)  capacitor c=31.1384a
    C409  (net24\#2 10)  capacitor c=798.071a
    C72  (S0 vss)  capacitor c=31.4766a
    C192  (Yn\#2319 S0)  capacitor c=290.439a
    C196  (10 S0)  capacitor c=7.58434e-15
    C73  (S0\#2310 vss)  capacitor c=23.2148a
    C197  (S0\#2310 10)  capacitor c=1.6774e-15
    C74  (S0\#6 vss)  capacitor c=22.5054a
    C147  (S0\#6 A\#3)  capacitor c=11.3512a
    C198  (S0\#6 10)  capacitor c=1.6194e-15
    C75  (S0\#1 vss)  capacitor c=8.11387e-18
    C199  (S0\#1 10)  capacitor c=1.28441e-15
    C76  (S0\#7 vss)  capacitor c=31.1688a
    C169  (S0\#7 S1)  capacitor c=357.702a
    C172  (S1\#2 S0\#7)  capacitor c=2.09231e-18
    C201  (S0\#7 10)  capacitor c=2.77203e-15
    C212  (S0\#7 net23)  capacitor c=11.6294a
    C366  (Yn\#7 net23)  capacitor c=11.0633a
    C189  (Yn\#7 S0\#7)  capacitor c=164.203a
    C213  (S0\#7 net22)  capacitor c=167.806a
    C368  (Yn\#7 net22)  capacitor c=50.7743a
    C390  (S1n\#3 net22)  capacitor c=24.8907a
    C124  (vss\#3 S1n\#3)  capacitor c=1.83342e-15
    C279  (S1n\#3 S1)  capacitor c=1.08429e-15
    C283  (S1\#2 S1n\#3)  capacitor c=6.34357e-18
    C285  (S1\#4 S1n\#3)  capacitor c=2.07938e-19
    C383  (S1n\#3 10)  capacitor c=14.5948f
    C135  (net23\#2 vss\#8)  capacitor c=69.04a
    C80  (S0\#5 vss)  capacitor c=11.7653a
    C148  (S0\#5 A\#3)  capacitor c=591.032a
    C181  (S0\#5 S0n\#8)  capacitor c=39.1184a
    C194  (Yn\#2319 S0\#5)  capacitor c=1.27455e-15
    C206  (S0\#5 10)  capacitor c=7.1302e-15
    C171  (S0\#8 S1\#3)  capacitor c=293.197a
    C183  (S0n\#7 S0\#5)  capacitor c=2.06924e-15
    C88  (S1\#3 vss)  capacitor c=25.6997a
    C103  (S0n\#7 vss)  capacitor c=19.8689a
    C151  (S0n\#7 A\#3)  capacitor c=604.471a
    C182  (S0n\#7 S0)  capacitor c=1.14401e-15
    C221  (vdd\#4 S1\#3)  capacitor c=1.77983e-15
    C272  (S0n\#2311 S1\#3)  capacitor c=279.397a
    C273  (S0n\#8 S1\#3)  capacitor c=300.735a
    C287  (S1\#3 10)  capacitor c=7.33703e-15
    C296  (S1\#3 net12)  capacitor c=52.0986a
    C317  (Yn\#2319 S0n\#7)  capacitor c=2.28989e-15
    C328  (S0n\#7 10)  capacitor c=18.0177f
    C84  (C\#3 vss)  capacitor c=2.1642e-18
    C167  (S0\#2310 C\#3)  capacitor c=11.3512a
    C168  (S0\#9 C\#3)  capacitor c=591.032a
    C219  (vdd\#2 C\#3)  capacitor c=14.4998a
    C255  (S0n\#2311 C\#3)  capacitor c=604.471a
    C257  (C\#3 S1n\#5)  capacitor c=25.1533a
    C259  (C\#3 10)  capacitor c=3.90436e-15
    C85  (C\#4 vss)  capacitor c=14.0569a
    C260  (C\#4 10)  capacitor c=599.382a
    C268  (net20\#4 C\#4)  capacitor c=83.9654a
    C86  (C\#2 vss)  capacitor c=3.00591e-18
    C261  (C\#2 10)  capacitor c=4.12427e-15
    C269  (C\#2 net20\#4)  capacitor c=556.105a
    C87  (vss\#3 C)  capacitor c=227.666a
    C258  (10 C)  capacitor c=2.91212e-15
    C266  (net20\#2 C)  capacitor c=66.6915a
    C267  (net20\#4 C)  capacitor c=74.948a
    C264  (net21 C)  capacitor c=82.3047a
    C139  (vss\#3 net21)  capacitor c=104.285a
    C265  (C\#4 net21)  capacitor c=117.579a
    C415  (net21 10)  capacitor c=661.115a
    C442  (net20\#4 net21)  capacitor c=50.7743a
    C370  (Yn\#2315 net20\#4)  capacitor c=11.6374a
    C118  (vss\#3 Yn\#2315)  capacitor c=41.374a
    C140  (vss\#3 net21\#2)  capacitor c=108.933a
    C301  (net21\#2 S1)  capacitor c=16.6955a
    C369  (Yn\#2315 net21\#2)  capacitor c=50.7743a
    C416  (net21\#2 10)  capacitor c=822.047a
    C89  (S1\#5 vss)  capacitor c=7.36747e-18
    C150  (A\#3 S1\#5)  capacitor c=11.0549a
    C288  (S1\#5 10)  capacitor c=201.503a
    C90  (S1\#8 vss)  capacitor c=15.9584a
    C254  (C\#2 S1\#8)  capacitor c=583.92a
    C256  (C\#2 Yn\#2312)  capacitor c=598.213a
    C186  (Yn\#2312 S0\#9)  capacitor c=1.70578e-15
    C195  (S0\#9 S1n)  capacitor c=1.04443e-15
    C119  (S1n vss)  capacitor c=27.2363a
    C232  (vdd\#2 S1n)  capacitor c=1.24767e-15
    C275  (Yn\#2317 S1\#8)  capacitor c=273.179a
    C291  (S1\#8 10)  capacitor c=5.15608e-15
    C303  (net20\#2 S1\#8)  capacitor c=365.27a
    C318  (S0n\#2311 S1n)  capacitor c=1.07097e-15
    C349  (S1n\#3 Yn\#2312)  capacitor c=1.13144e-15
    C380  (10 S1n)  capacitor c=13.7672f
    C280  (S1n\#4 S1)  capacitor c=75.0217a
    C284  (S1\#2 S1n\#4)  capacitor c=4.38824e-19
    C384  (S1n\#4 10)  capacitor c=218.213a
    C91  (vss\#6 S1\#9)  capacitor c=99.584a
    C302  (net20\#2 S1\#9)  capacitor c=487.284a
    C289  (S1\#9 10)  capacitor c=1.78412e-15
    C111  (Yn\#20 vss)  capacitor c=8.89043e-18
    C187  (Yn\#20 S0\#2312)  capacitor c=185.484a
    C373  (Yn\#20 net19)  capacitor c=50.3566a
    C112  (Yn\#2314 vss)  capacitor c=7.689e-18
    C188  (Yn\#2314 S0\#2310)  capacitor c=205.274a
    C230  (vdd\#4 Yn\#2314)  capacitor c=21.8788a
    C312  (Yn\#2314 S0n\#2311)  capacitor c=2.22438e-15
    C350  (Yn\#2314 S1n)  capacitor c=87.8062a
    C92  (vss\#7 S1)  capacitor c=112.043a
    C271  (S0n\#2310 S1)  capacitor c=1.05068e-15
    C94  (S1\#2 vss\#7)  capacitor c=5.94887e-19
    C93  (vss\#7 S1\#1)  capacitor c=137.134a
    C106  (vss\#3 S0n\#2310)  capacitor c=31.9979a
    C114  (Yn\#7 vss\#7)  capacitor c=104.583a
    C113  (Yn\#9 vss)  capacitor c=21.962a
    C121  (vss\#7 S1n\#4)  capacitor c=60.4731a
    C281  (S1n\#4 S1\#1)  capacitor c=80.8146a
    C290  (S1\#1 10)  capacitor c=779.961a
    C311  (Yn\#2315 S0n\#2310)  capacitor c=1.08483e-15
    C345  (net21\#2 S0n\#2310)  capacitor c=117.579a
    C313  (Yn\#9 S0n\#9)  capacitor c=213.408a
    C314  (Yn\#9 S0n\#8)  capacitor c=1.24568e-15
    C225  (vdd\#7 S0n\#8)  capacitor c=66.9292a
    C229  (Yn\#9 vdd\#7)  capacitor c=101.411a
    C323  (S0n\#2310 10)  capacitor c=5.75338e-15
    C356  (Yn\#9 net11)  capacitor c=6.40621e-18
    C358  (Yn\#9 net12)  capacitor c=84.6238a
    C347  (S0n\#9 X38_5)  capacitor c=515.346a
    C378  (Yn\#9 X38_5)  capacitor c=163.003a
    C429  (X38_5 net12)  capacitor c=158.892a
    C96  (S0n vss)  capacitor c=14.598a
    C175  (S0n S0)  capacitor c=19.4323a
    C207  (S0\#2 10)  capacitor c=7.06578e-18
    C320  (10 S0n)  capacitor c=4.01253e-15
    C202  (S0\#4 10)  capacitor c=2.87757e-15
    C82  (vss\#5 S0\#4)  capacitor c=171.039a
    C184  (S0n\#5 S0\#4)  capacitor c=91.8565a
    C104  (S0n\#5 vss)  capacitor c=215.454a
    C329  (S0n\#5 10)  capacitor c=7.25191e-15
    C344  (S0n\#5 net24\#2)  capacitor c=5.29994e-18
    C316  (S0n\#5 Yn\#5)  capacitor c=70.0369a
    C295  (S1\#4 net11\#2)  capacitor c=536.679a
    C307  (S1\#4 X36_5)  capacitor c=90.3214a
    C387  (net14\#2 S1n)  capacitor c=190.681a
    C243  (vdd\#6 net13\#2)  capacitor c=110.706a
    C249  (vdd\#6 X42_5)  capacitor c=354.77a
    C388  (net13\#2 S1n\#5)  capacitor c=235.042a
    C392  (S1n\#5 X42_5)  capacitor c=452.146a
    C436  (net13\#2 X42_5)  capacitor c=318.067a
    C386  (S1n\#5 net14)  capacitor c=108.908a
    C241  (vdd\#2 net14)  capacitor c=150.229a
    C242  (vdd\#2 net14\#2)  capacitor c=140.986a
    C244  (vdd\#2 net13\#4)  capacitor c=17.259a
    C431  (net13\#4 net14)  capacitor c=84.6238a
    C129  (net14\#2 vss)  capacitor c=2.19832e-18
    C99  (S0n\#6 vss)  capacitor c=32.1743a
    C105  (S0n\#4 vss)  capacitor c=5.52211e-18
    C107  (Yn vss)  capacitor c=3.43533e-18
    C115  (Yn\#5 vss)  capacitor c=112.588a
    C315  (Yn\#5 S0n\#6)  capacitor c=1.13956e-15
    C116  (Yn\#4 vss)  capacitor c=4.94229e-18
    C122  (S1n\#2 vss)  capacitor c=2.80044e-18
    C126  (net10 vss)  capacitor c=2.40473e-18
    C127  (net11\#4 vss)  capacitor c=1.44162e-18
    C146  (X39_5 vss)  capacitor c=9.91316e-18
    C357  (Yn\#4 net11\#4)  capacitor c=11.5216a
    C393  (S1n\#2 X39_5)  capacitor c=314.732a
    C422  (net11\#4 net10)  capacitor c=84.6238a
    C157  (A\#3 net10)  capacitor c=171.272a
    C158  (net11\#4 A\#3)  capacitor c=636.352a
    C165  (A\#3 X35_5)  capacitor c=528.607a
    C423  (X35_5 net10)  capacitor c=152.718a
    C428  (net11\#4 X35_5)  capacitor c=161.018a
    C185  (S0n\#4 S0\#1)  capacitor c=134.691a
    C166  (vdd\#5 S0\#1)  capacitor c=221.172a
    C226  (S0n\#4 vdd\#5)  capacitor c=144.594a
    C218  (S0\#1 X33_5)  capacitor c=530.351a
    C253  (vdd\#5 X33_5)  capacitor c=408.586a
    C348  (S0n\#4 X33_5)  capacitor c=318.488a
    C227  (Yn vdd)  capacitor c=21.1579a
    C190  (Yn\#4 S0\#6)  capacitor c=205.274a
    C209  (net11\#4 S0\#6)  capacitor c=11.6294a
    C208  (net10\#2 S0\#6)  capacitor c=221.034a
    C235  (net10\#2 vdd)  capacitor c=142.129a
    C355  (net10\#2 Yn\#4)  capacitor c=84.6238a
    C217  (S0\#6 X34_5)  capacitor c=526.552a
    C379  (Yn\#4 X34_5)  capacitor c=163.003a
    C424  (net10\#2 X34_5)  capacitor c=152.502a
    C210  (net14\#2 S0\#2310)  capacitor c=279.492a
    C211  (net13\#4 S0\#2310)  capacitor c=11.6294a
    C216  (S0\#2310 X40_5)  capacitor c=518.043a
    C359  (net14\#2 Yn\#2314)  capacitor c=84.6238a
    C361  (Yn\#2314 net13\#4)  capacitor c=11.5216a
    C377  (Yn\#2314 X40_5)  capacitor c=163.003a
    C433  (net14\#2 X40_5)  capacitor c=158.676a
    C223  (S0n vdd)  capacitor c=105.594a
    C236  (vdd\#4 net10)  capacitor c=157.515a
    C394  (net10 10)  capacitor c=508.207a
    C238  (vdd\#4 net11\#4)  capacitor c=17.0835a
    C308  (Yn S0n)  capacitor c=40.8148a
    C324  (S0n\#6 10)  capacitor c=5.84596e-15
    C330  (S0n\#4 10)  capacitor c=79.2239a
    C331  (net10\#2 S0n)  capacitor c=46.1398a
    C385  (S1n\#2 10)  capacitor c=78.2895a
    C395  (net10\#2 10)  capacitor c=519.285a
    C332  (net10\#2 S0n\#7)  capacitor c=19.8327a
    C335  (net11\#4 S0n\#7)  capacitor c=207.179a
    C398  (net11\#4 10)  capacitor c=193.806a
    C401  (net14 10)  capacitor c=483.639a
    C402  (net14\#2 10)  capacitor c=521.91a
    C404  (net13\#2 10)  capacitor c=725.612a
    C405  (net13\#4 10)  capacitor c=184.747a
    C397  (net11\#2 10)  capacitor c=500.469a
    C237  (vdd\#8 net11\#2)  capacitor c=109.969a
    C220  (vdd\#8 S1\#5)  capacitor c=144.16a
    C294  (net11\#2 S1\#5)  capacitor c=147.756a
    C252  (vdd\#8 X36_5)  capacitor c=309.688a
    C306  (S1\#5 X36_5)  capacitor c=356.882a
    C427  (net11\#2 X36_5)  capacitor c=316.116a
    C231  (S1n\#2 vdd\#7)  capacitor c=112.285a
    C250  (vdd\#7 X39_5)  capacitor c=159.682a
    C305  (S1\#3 X39_5)  capacitor c=493.009a
    C282  (S1n\#2 S1\#3)  capacitor c=134.691a
    C262  (C\#3 net14)  capacitor c=211.809a
    C263  (net13\#4 C\#3)  capacitor c=667.507a
    C270  (C\#3 X41_5)  capacitor c=520.137a
    C432  (X41_5 net14)  capacitor c=158.892a
    C437  (net13\#4 X41_5)  capacitor c=161.018a
    C340  (net13\#4 S0n\#2311)  capacitor c=205.474a
    C319  (S1n\#2 S0n\#2311)  capacitor c=71.675a
    C338  (net14\#2 S0n\#2311)  capacitor c=19.8327a
    C343  (net24\#2 S0n\#6)  capacitor c=118.603a
    C364  (Yn\#5 net24\#2)  capacitor c=53.572a
    MX56_M0_unmatched  (net19\#2 D\#2 net20 net20)  nch w=2e-06 l=1e-06 as=0 \
        ad=5e-12 ps=0 pd=9e-06 sa=2e-06 sb=2e-06
    MX58_M0_unmatched  (Y\#1 Yn\#24 vss\#1 vss\#1)  nch w=2e-06 l=1e-06 \
        as=0 ad=5e-12 ps=0 pd=9e-06 sa=2e-06 sb=2e-06
    MX50_M0_unmatched  (net22\#2 B\#2 net23 net23)  nch w=2e-06 l=1e-06 as=0 \
        ad=5e-12 ps=0 pd=9e-06 sa=2e-06 sb=2e-06
    MX48_M0_unmatched  (net24 A\#4 net23\#4 net23\#4)  nch w=2e-06 l=1e-06 \
        as=0 ad=5e-12 ps=0 pd=9e-06 sa=2e-06 sb=2e-06
    MX51_M0_unmatched  (Yn\#7 S0\#7 net22 net22)  nch w=2e-06 l=1e-06 as=0 \
        ad=5e-12 ps=0 pd=9e-06 sa=2e-06 sb=2e-06
    MX49_M0_unmatched  (net23\#2 S1n\#6 vss\#8 vss\#8)  nch w=2e-06 \
        l=1e-06 as=0 ad=5e-12 ps=0 pd=9e-06 sa=2e-06 sb=2e-06
    MX54_M0_unmatched  (net21 C\#4 net20\#4 net20\#4)  nch w=2e-06 l=1e-06 \
        as=0 ad=5e-12 ps=0 pd=9e-06 sa=2e-06 sb=2e-06
    MX55_M0_unmatched  (net20\#2 S1\#9 vss\#6 vss\#6)  nch w=2e-06 l=1e-06 \
        as=0 ad=5e-12 ps=0 pd=9e-06 sa=2e-06 sb=2e-06
    MX57_M0_unmatched  (Yn\#20 S0\#2312 net19 net19)  nch w=2e-06 l=1e-06 \
        as=0 ad=5e-12 ps=0 pd=9e-06 sa=2e-06 sb=2e-06
    MX52_M0_unmatched  (S1n\#4 S1\#1 vss\#7 vss\#7)  nch w=2e-06 l=1e-06 \
        as=0 ad=5e-12 ps=0 pd=9e-06 sa=2e-06 sb=2e-06
    MX53_M0_unmatched  (Yn\#2315 S0n\#2310 net21\#2 net21\#2)  nch w=2e-06 \
        l=1e-06 as=0 ad=5e-12 ps=0 pd=9e-06 sa=2e-06 sb=2e-06
    MX46_M0_unmatched  (S0n\#5 S0\#4 vss\#5 vss\#5)  nch w=2e-06 l=1e-06 \
        as=0 ad=5e-12 ps=0 pd=9e-06 sa=2e-06 sb=2e-06
    MX47_M0_unmatched  (Yn\#5 S0n\#6 net24\#2 net24\#2)  nch w=2e-06 l=1e-06 \
        as=0 ad=5e-12 ps=0 pd=9e-06 sa=2e-06 sb=2e-06
    MX45_M0_unmatched  (Y\#2 Yn\#22 vdd\#1 vdd\#1)  pch w=4e-06 l=1e-06 \
        as=0 ad=1e-11 ps=0 pd=1.3e-05 sa=2e-06 sb=2e-06
    MX43_M0_unmatched  (net15\#2 D\#4 net13 net13)  pch w=4e-06 l=1e-06 as=0 \
        ad=1e-11 ps=0 pd=1.3e-05 sa=2e-06 sb=2e-06
    MX44_M0_unmatched  (Yn\#21 S0n\#2313 net15 net15)  pch w=4e-06 l=1e-06 \
        as=0 ad=1e-11 ps=0 pd=1.3e-05 sa=2e-06 sb=2e-06
    MX37_M0_unmatched  (net12\#2 B\#4 net11 net11)  pch w=4e-06 l=1e-06 as=0 \
        ad=1e-11 ps=0 pd=1.3e-05 sa=2e-06 sb=2e-06
    MX38_M0_unmatched  (Yn\#9 S0n\#9 net12 net12)  pch w=4e-06 l=1e-06 as=0 \
        ad=1e-11 ps=0 pd=1.3e-05 sa=2e-06 sb=2e-06
    MX42_M0_unmatched  (net13\#2 S1n\#5 vdd\#6 vdd\#6)  pch w=4e-06 \
        l=1e-06 as=0 ad=1e-11 ps=0 pd=1.3e-05 sa=2e-06 sb=2e-06
    MX35_M0_unmatched  (net10 A\#3 net11\#4 net11\#4)  pch w=4e-06 l=1e-06 \
        as=0 ad=1e-11 ps=0 pd=1.3e-05 sa=2e-06 sb=2e-06
    MX33_M0_unmatched  (S0n\#4 S0\#1 vdd\#5 vdd\#5)  pch w=4e-06 l=1e-06 \
        as=0 ad=1e-11 ps=0 pd=1.3e-05 sa=2e-06 sb=2e-06
    MX34_M0_unmatched  (Yn\#4 S0\#6 net10\#2 net10\#2)  pch w=4e-06 l=1e-06 \
        as=0 ad=1e-11 ps=0 pd=1.3e-05 sa=2e-06 sb=2e-06
    MX40_M0_unmatched  (Yn\#2314 S0\#2310 net14\#2 net14\#2)  pch w=4e-06 \
        l=1e-06 as=0 ad=1e-11 ps=0 pd=1.3e-05 sa=2e-06 sb=2e-06
    MX36_M0_unmatched  (net11\#2 S1\#5 vdd\#8 vdd\#8)  pch w=4e-06 l=1e-06 \
        as=0 ad=1e-11 ps=0 pd=1.3e-05 sa=2e-06 sb=2e-06
    MX39_M0_unmatched  (S1n\#2 S1\#3 vdd\#7 vdd\#7)  pch w=4e-06 l=1e-06 \
        as=0 ad=1e-11 ps=0 pd=1.3e-05 sa=2e-06 sb=2e-06
    MX41_M0_unmatched  (net14 C\#3 net13\#4 net13\#4)  pch w=4e-06 l=1e-06 \
        as=0 ad=1e-11 ps=0 pd=1.3e-05 sa=2e-06 sb=2e-06
    Rc60  (vdd\#2 vdd\#6)  resistor r=2.5488
    Rd3  (S1\#4 S1)  resistor r=2623.001
    Rd10  (vss vss\#3)  resistor r=580.9m
    Rs1  (10 vss)  resistor r=50
    Rd41  (D\#3 D\#2)  resistor r=163.6361
    Rc41  (D\#3 D\#4)  resistor r=3903.0679
    Rc43  (D\#3 D)  resistor r=288.8155
    Rd26  (S0\#2312 S0\#2311)  resistor r=2248.2666
    Rc58  (vdd\#1 vdd\#2)  resistor r=2.8538
    Rc32  (vdd\#2 vdd\#4)  resistor r=593.4m
    Rc22  (S0\#2311 S0\#9)  resistor r=5.9
    Rd13  (Yn\#2317 Yn\#2319)  resistor r=1.6885
    Rc46  (net15 net15\#2)  resistor r=5.35
    Rd21  (net20 net20\#2)  resistor r=15.3
    Rc2  (net20 net20\#4)  resistor r=16.218
    Rd20  (net20\#2 net20\#4)  resistor r=15.3
    Rc56  (Y Y\#2)  resistor r=2.875
    Rc55  (Y Y\#1)  resistor r=5.3
    Rd39  (Yn\#23 Yn\#2317)  resistor r=85.557
    Rc28  (Yn\#22 Yn\#23)  resistor r=1936.0317
    Rd25  (Yn\#23 Yn\#24)  resistor r=1636.0317
    Rd14  (Yn\#2317 Yn\#21)  resistor r=2.7805
    Rc3  (S0n\#2313 S0n\#2312)  resistor r=966.0984
    Rd42  (S0n\#2312 S0n\#2311)  resistor r=6
    Rc45  (net19 net19\#2)  resistor r=10.2
    Rd31  (vss\#1 vss\#3)  resistor r=5.9834
    Rc61  (vss\#1 vss\#6)  resistor r=91.6803
    Rc57  (vss\#6 vss\#3)  resistor r=5.7497
    Rd29  (B\#3 B\#4)  resistor r=3903.0679
    Rc42  (B\#3 B\#2)  resistor r=163.6361
    Rd16  (B\#3 B)  resistor r=288.8155
    Rc21  (S0\#9 S0\#8)  resistor r=0.8
    Rc50  (S1\#2 S1\#4)  resistor r=448344.2812
    Rc40  (S1\#2 S1)  resistor r=85.9804
    Rd44  (S0n\#2311 S0n\#8)  resistor r=0.7
    Rc52  (S0n\#8 S0n\#9)  resistor r=1128.2664
    Rc15  (net12 net12\#2)  resistor r=5.3
    Rc16  (net22 net22\#2)  resistor r=10.2
    Rc38  (net23 net23\#2)  resistor r=15.3
    Rd9  (A\#2 A\#4)  resistor r=163.6361
    Rc44  (A\#2 A\#3)  resistor r=3753.0679
    Rc36  (A\#2 A)  resistor r=288.8155
    Rc5  (net24 net24\#2)  resistor r=10.2
    Rd36  (net23 net23\#4)  resistor r=16.218
    Rc39  (net23\#2 net23\#4)  resistor r=15.3
    Rd27  (S0\#9 S0\#2310)  resistor r=1571.0985
    Rd18  (S0\#7 S0\#8)  resistor r=2253.2666
    Rd35  (S1n\#3 S1n\#6)  resistor r=6157.0752
    Rd11  (Yn\#7 Yn\#2319)  resistor r=554.1891
    Rd32  (vss\#3 vss\#8)  resistor r=8.8917
    Rc63  (vss vss\#8)  resistor r=12.7258
    Rd19  (S0\#5 S0\#6)  resistor r=1571.0985
    Rd7  (S0\#5 S0)  resistor r=0.4
    Rc18  (S0\#8 S0\#5)  resistor r=0.9
    Rd43  (S0n\#8 S0n\#7)  resistor r=1
    Rd1  (S1\#3 S1\#4)  resistor r=5486.8765
    Rc54  (S1\#2 S1\#3)  resistor r=2236.0317
    Rd4  (C\#2 C\#3)  resistor r=3753.0679
    Rc37  (C\#2 C\#4)  resistor r=163.6361
    Rd5  (C\#2 C)  resistor r=288.8155
    Rc23  (net21 net21\#2)  resistor r=10.2
    Rc49  (S1\#4 S1\#5)  resistor r=163.6361
    Rd33  (S1n\#5 S1n)  resistor r=4807.0757
    Rd34  (S1n S1n\#3)  resistor r=1435.853
    Rc20  (S1n\#3 S1n\#4)  resistor r=10.1
    Rd2  (S1\#8 S1)  resistor r=5.5
    Rd17  (S1\#8 S1\#9)  resistor r=1123.2664
    Rc69  (Yn\#2312 Yn\#2315)  resistor r=546.053
    Rc71  (Yn\#2312 Yn\#2317)  resistor r=21.1057
    Rc66  (Yn\#2317 Yn\#20)  resistor r=5.193
    Rc68  (Yn\#2312 Yn\#2319)  resistor r=7.0764
    Rd38  (Yn\#2312 Yn\#2314)  resistor r=843.478
    Rd8  (S1\#2 S1\#1)  resistor r=436.0318
    Rc62  (vss\#3 vss\#7)  resistor r=5.1974
    Rc65  (Yn\#9 Yn\#7)  resistor r=93494.7969
    Rc47  (S0n\#2310 S0n\#2311)  resistor r=1681.9572
    Rc67  (Yn\#9 Yn\#2319)  resistor r=856.2532
    Rc64  (vdd\#2 vdd\#7)  resistor r=6.1717
    Rc11  (vdd\#7 vdd\#4)  resistor r=5.1664
    Rc4  (S0\#2 S0)  resistor r=85.564
    Rd40  (S0n\#7 S0n)  resistor r=394.9496
    Rc17  (S0\#1 S0\#2)  resistor r=1336.0317
    Rd6  (S0\#2 S0\#4)  resistor r=2236.0317
    Rd12  (vss vss\#5)  resistor r=5.0972
    Rd28  (S0n\#7 S0n\#5)  resistor r=1470.5142
    Rc53  (S0n S0n\#5)  resistor r=109822.7969
    Rc72  (Yn Yn\#2319)  resistor r=856.8542
    Rd15  (Yn\#5 Yn\#2319)  resistor r=556.4442
    Rc1  (net13 net13\#2)  resistor r=7.6545
    Rd24  (net13 net13\#4)  resistor r=8.42
    Rc27  (net11 net11\#4)  resistor r=8.42
    Rd22  (net11 net11\#2)  resistor r=7.6545
    Rc19  (S1n S1n\#2)  resistor r=5.05
    Rc24  (net14 net14\#2)  resistor r=5.25
    Rc26  (net13\#2 net13\#4)  resistor r=7.7963
    Rd37  (Yn Yn\#5)  resistor r=74267.8984
    Rc70  (Yn Yn\#4)  resistor r=2.625
    Rd30  (vdd vdd\#5)  resistor r=2.6222
    Rc6  (net10 net10\#2)  resistor r=5.25
    Rc59  (vdd vdd\#4)  resistor r=307.3m
    Rc7  (vdd\#4 vdd\#8)  resistor r=2.5488
    Rc48  (S0n S0n\#4)  resistor r=2.55
    Rc51  (S0n\#6 S0n\#7)  resistor r=1681.9572
    Rd23  (net11\#2 net11\#4)  resistor r=7.7963
ends MX4X1
