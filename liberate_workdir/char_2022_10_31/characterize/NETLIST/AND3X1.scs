// AND3X1
simulator lang=spectre insensitive=yes
global vss vdd
subckt AND3X1 A B C Y
    C2  (vdd\#1 Y\#2)  capacitor c=140.489a
    C8  (vdd\#1 YN\#8)  capacitor c=238.805a
    C40  (Y\#2 vss)  capacitor c=6.16489e-18
    C44  (Y\#2 YN\#8)  capacitor c=189.321a
    C48  (Y\#2 5)  capacitor c=1.29052e-15
    C72  (YN\#8 vss)  capacitor c=1.92677e-18
    C76  (5 vss)  capacitor c=8.99336e-15
    C98  (YN\#8 5)  capacitor c=587.847a
    C5  (vdd\#5 vss)  capacitor c=32.401a
    C1  (vdd\#5 C\#2)  capacitor c=234.793a
    C18  (Y\#2 C\#2)  capacitor c=3.46027e-18
    C21  (C\#2 vss)  capacitor c=13.3734a
    C33  (C\#2 5)  capacitor c=2.42858e-15
    C7  (vdd\#1 YN)  capacitor c=30.4104a
    C43  (Y\#2 YN)  capacitor c=191.195a
    C97  (5 YN)  capacitor c=15.033f
    C9  (vdd\#5 YN\#6)  capacitor c=176.284a
    C12  (vdd\#2 5)  capacitor c=19.3577f
    C13  (vdd\#1 X7_5)  capacitor c=212.366a
    C50  (Y\#2 X7_5)  capacitor c=406.72a
    C103  (YN\#8 X7_5)  capacitor c=508.173a
    C42  (YN Y)  capacitor c=324.88a
    C47  (5 Y)  capacitor c=2.8092e-15
    C31  (YN\#2 C\#2)  capacitor c=868.448a
    C75  (YN\#2 vss)  capacitor c=40.4575a
    C99  (YN\#2310 5)  capacitor c=3.41776e-15
    C104  (YN\#6 X6_5)  capacitor c=148.996a
    C14  (vdd\#5 X6_5)  capacitor c=148.996a
    C39  (C\#2 X6_5)  capacitor c=531.824a
    C19  (C\#3 Y)  capacitor c=4.63684e-19
    C23  (C\#3 vss)  capacitor c=4.71862e-19
    C35  (C\#3 5)  capacitor c=356.561a
    C17  (Y C)  capacitor c=7.31565e-18
    C20  (vss C)  capacitor c=17.2322a
    C32  (5 C)  capacitor c=6.33588e-15
    C45  (Y\#1 YN\#2310)  capacitor c=372.885a
    C49  (Y\#1 5)  capacitor c=1.408e-15
    C24  (B C)  capacitor c=20.9712a
    C26  (C\#3 B)  capacitor c=1.3292e-18
    C68  (B vss)  capacitor c=14.8878a
    C85  (YN\#2 B)  capacitor c=15.8185a
    C88  (5 B)  capacitor c=6.82949e-15
    C25  (B\#3 C)  capacitor c=1.3292e-18
    C27  (C\#3 B\#3)  capacitor c=8.42481e-20
    C71  (B\#3 vss)  capacitor c=6.63178e-19
    C87  (YN\#2 B\#3)  capacitor c=3.30853e-19
    C91  (B\#3 5)  capacitor c=373.386a
    C28  (YN\#5 C)  capacitor c=531.57a
    C36  (net3 C)  capacitor c=46.786a
    C30  (C\#3 YN\#5)  capacitor c=30.4744a
    C38  (C\#3 net3)  capacitor c=1.09427e-19
    C29  (YN\#5 C\#4)  capacitor c=167.909a
    C34  (C\#4 5)  capacitor c=1.46409e-15
    C37  (C\#4 net3)  capacitor c=83.616a
    C46  (YN\#5 Y\#1)  capacitor c=16.7262a
    C100  (YN\#2310 net3)  capacitor c=1.12473e-18
    C101  (YN\#5 net3)  capacitor c=46.0379a
    C109  (net3 5)  capacitor c=236.848a
    C22  (vss\#1 C\#4)  capacitor c=75.9502a
    C74  (YN\#5 vss\#1)  capacitor c=91.0597a
    C41  (vss\#1 Y\#1)  capacitor c=110.858a
    C73  (vss\#1 YN\#2310)  capacitor c=187.568a
    C77  (vss\#1 5)  capacitor c=10.4233f
    C82  (vss\#1 net3)  capacitor c=72.6356a
    C83  (net3\#2 vss)  capacitor c=53.3931a
    C84  (net3\#2 vss\#1)  capacitor c=20.7382a
    C102  (YN\#2 net3\#2)  capacitor c=1.56407e-18
    C110  (net3\#2 5)  capacitor c=237.976a
    C51  (vss A)  capacitor c=9.61101e-18
    C55  (B A)  capacitor c=14.9774a
    C57  (B\#3 A)  capacitor c=4.30717e-19
    C62  (5 A)  capacitor c=6.66152e-15
    C3  (vdd\#4 A)  capacitor c=19.3507a
    C4  (vdd\#4 A\#2)  capacitor c=238.688a
    C52  (A\#2 vss)  capacitor c=9.55466e-18
    C63  (A\#2 5)  capacitor c=1.26397e-15
    C11  (vdd\#4 YN\#4)  capacitor c=178.905a
    C59  (YN\#4 A)  capacitor c=134.368a
    C54  (A\#3 vss)  capacitor c=5.58326e-19
    C56  (A\#3 B)  capacitor c=9.49303e-19
    C92  (net4 B)  capacitor c=12.1712a
    C58  (B\#3 A\#3)  capacitor c=2.72999e-20
    C60  (YN\#4 A\#2)  capacitor c=258.561a
    C61  (A\#3 YN\#4)  capacitor c=4.94174e-18
    C65  (A\#3 5)  capacitor c=378.266a
    C79  (net4 vss)  capacitor c=74.1313a
    C94  (B\#3 net4)  capacitor c=7.71439e-19
    C107  (net4 5)  capacitor c=299.333a
    C111  (net3\#2 net4)  capacitor c=39.8112a
    C64  (A\#4 5)  capacitor c=2.78908e-15
    C67  (A\#2 X4_5)  capacitor c=531.582a
    C16  (vdd\#4 X4_5)  capacitor c=437.382a
    C106  (YN\#4 X4_5)  capacitor c=181.705a
    C86  (YN\#2 B\#2)  capacitor c=821.295a
    C69  (B\#2 vss)  capacitor c=14.6898a
    C89  (B\#2 5)  capacitor c=2.45053e-15
    C70  (B\#4 vss)  capacitor c=74.9293a
    C90  (B\#4 5)  capacitor c=1.45623e-15
    C93  (B\#4 net4)  capacitor c=83.616a
    C95  (net3\#2 B\#4)  capacitor c=83.616a
    C66  (net4\#2 A\#4)  capacitor c=83.616a
    C80  (net4\#2 vss)  capacitor c=66.4358a
    C53  (vss\#2 A\#4)  capacitor c=191.712a
    C78  (vss\#2 5)  capacitor c=527.888a
    C81  (vss\#2 net4\#2)  capacitor c=39.1322a
    C108  (net4\#2 5)  capacitor c=238.004a
    C6  (vdd\#6 B\#2)  capacitor c=234.793a
    C10  (vdd\#6 YN\#7)  capacitor c=230.145a
    C15  (vdd\#6 X5_5)  capacitor c=148.996a
    C96  (B\#2 X5_5)  capacitor c=531.824a
    C105  (YN\#7 X5_5)  capacitor c=148.996a
    MX7_M0_unmatched  (Y\#2 YN\#8 vdd\#1 vdd\#1)  pch w=4e-06 l=1e-06 as=0 \
        ad=1e-11 ps=0 pd=1.3e-05 sa=2e-06 sb=2e-06
    MX6_M0_unmatched  (YN\#6 C\#2 vdd\#5 vdd\#5)  pch w=4e-06 l=1e-06 as=0 \
        ad=1e-11 ps=0 pd=1.3e-05 sa=2e-06 sb=2e-06
    MX4_M0_unmatched  (YN\#4 A\#2 vdd\#4 vdd\#4)  pch w=4e-06 l=1e-06 as=0 \
        ad=1e-11 ps=0 pd=1.3e-05 sa=2e-06 sb=2e-06
    MX5_M0_unmatched  (YN\#7 B\#2 vdd\#6 vdd\#6)  pch w=4e-06 l=1e-06 as=0 \
        ad=1e-11 ps=0 pd=1.3e-05 sa=2e-06 sb=2e-06
    Rs1  (5 vss)  resistor r=50
    Rd6  (vdd\#2 vdd\#1)  resistor r=2.6962
    Rc13  (Y Y\#2)  resistor r=2.875
    Rc8  (YN\#8 YN\#9)  resistor r=736.0318
    Rc7  (YN\#9 YN)  resistor r=80.464
    Rd8  (YN\#9 YN\#2310)  resistor r=2836.0317
    Rd1  (YN YN\#2)  resistor r=5.093
    Rc17  (YN\#2 YN\#6)  resistor r=2.668
    Rc19  (vdd\#2 vdd\#5)  resistor r=2.6224
    Rd10  (C\#2 C\#3)  resistor r=2536.0317
    Rc12  (Y Y\#1)  resistor r=5.3
    Rd12  (C\#3 C)  resistor r=85.564
    Rd9  (B\#3 B)  resistor r=85.564
    Rc6  (C\#3 C\#4)  resistor r=1036.0317
    Rd3  (YN\#2 YN\#5)  resistor r=5.493
    Rc5  (net3 net3\#2)  resistor r=10.1
    Rc20  (vss\#1 vss)  resistor r=5.3048
    Rc9  (A\#3 A)  resistor r=85.564
    Rd2  (YN\#2 YN\#4)  resistor r=3.2474
    Rc10  (A\#2 A\#3)  resistor r=1336.0317
    Rd11  (A\#3 A\#4)  resistor r=2236.0317
    Rd4  (vdd vdd\#4)  resistor r=2.6222
    Rc18  (YN\#7 YN\#4)  resistor r=45.1083
    Rc14  (YN\#2 YN\#7)  resistor r=3.0236
    Rd7  (B\#2 B\#3)  resistor r=2536.0317
    Rc11  (B\#3 B\#4)  resistor r=1036.0317
    Rc3  (net4 net4\#2)  resistor r=10.1
    Rc21  (vss vss\#2)  resistor r=5.0972
    Rc16  (vdd vdd\#2)  resistor r=0.134
    Rd5  (vdd\#2 vdd\#6)  resistor r=5.2977
    Rc15  (vdd vdd\#6)  resistor r=5.3242
    MX10_M0_unmatched  (YN\#5 C\#4 net3 net3)  nch w=2e-06 l=1e-06 as=0 \
        ad=5e-12 ps=0 pd=9e-06 sa=2e-06 sb=2e-06
    MX11_M0_unmatched  (Y\#1 YN\#2310 vss\#1 vss\#1)  nch w=2e-06 l=1e-06 \
        as=0 ad=5e-12 ps=0 pd=9e-06 sa=2e-06 sb=2e-06
    MX9_M0_unmatched  (net3\#2 B\#4 net4 net4)  nch w=2e-06 l=1e-06 as=0 \
        ad=5e-12 ps=0 pd=9e-06 sa=2e-06 sb=2e-06
    MX8_M0_unmatched  (net4\#2 A\#4 vss\#2 vss\#2)  nch w=2e-06 l=1e-06 \
        as=0 ad=5e-12 ps=0 pd=9e-06 sa=2e-06 sb=2e-06
ends AND3X1
