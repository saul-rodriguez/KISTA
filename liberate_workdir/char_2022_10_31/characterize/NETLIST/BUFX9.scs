// BUFX9
simulator lang=spectre insensitive=yes
global vss vdd
subckt BUFX9 A Y
    Rs1  (3 vss)  resistor r=50
    Rc16  (vss vss\#3)  resistor r=1.8139
    Rc11  (A\#2 A\#3)  resistor r=1336.0317
    Rc10  (A\#3 A\#4)  resistor r=436.0318
    Rc13  (A\#3 A)  resistor r=85.564
    Rc14  (vdd vdd\#3)  resistor r=1.0556
    Rc12  (vdd vdd\#4)  resistor r=1.1841
    Rd11  (Y Y\#5)  resistor r=1.1083
    Rc6  (YN\#4 YN\#3)  resistor r=3.4522
    Rc7  (YN YN\#4)  resistor r=9.6628
    Rd12  (YN YN\#3)  resistor r=14.5352
    Rc5  (Y Y\#3)  resistor r=1.9167
    Rd1  (vss vss\#1)  resistor r=2.0232
    Rd3  (vss vss\#4)  resistor r=1.9441
    Rd5  (YN\#8 YN)  resistor r=114.0987
    Rd9  (YN\#8 YN\#2313)  resistor r=1327.5659
    Rd2  (vdd vdd\#1)  resistor r=1.2668
    Rc17  (vdd\#1 vdd\#4)  resistor r=20.1609
    Rc4  (YN\#7 YN\#2311)  resistor r=1327.5659
    Rd4  (YN\#5 YN\#6)  resistor r=1336.0317
    Rd8  (YN\#6 YN\#7)  resistor r=258.7097
    Rc2  (YN\#6 YN\#9)  resistor r=436.0318
    Rd7  (Y Y\#1)  resistor r=1.3897
    Rd6  (Y Y\#4)  resistor r=2.405
    Rc8  (Y\#1 Y\#4)  resistor r=14.8205
    Rc3  (YN\#7 YN\#8)  resistor r=292.3445
    Rd10  (YN\#7 YN\#2310)  resistor r=427.5659
    Rc9  (YN\#8 YN\#2312)  resistor r=427.5659
    Rc15  (vss\#1 vss\#4)  resistor r=55.3272
    MM2  (YN\#3 A\#4 vss\#3 vss\#3)  nch w=6e-06 l=1e-06 as=0 ad=1.5e-11 \
        ps=0 pd=1.7e-05 sa=2e-06 sb=2e-06
    MM3  (Y\#4 YN\#9 vss\#1 vss\#1)  nch w=6e-06 l=1e-06 as=0 ad=1.5e-11 \
        ps=0 pd=1.7e-05 sa=2e-06 sb=2e-06
    MX5_M0_unmatched  (Y\#3 YN\#2312 vss\#4 vss\#4)  nch w=6e-06 l=1e-06 \
        as=1.8e-11 ad=0 ps=1.8e-05 pd=0 sa=2e-06 sb=2e-06
    MM4  (Y\#3 YN\#2310 vss\#1 vss\#1)  nch w=6e-06 l=1e-06 as=0 \
        ad=1.8e-11 ps=0 pd=1.8e-05 sa=2e-06 sb=2e-06
    C27  (vdd\#4 Y\#5)  capacitor c=477.712a
    C31  (vdd\#4 YN\#2313)  capacitor c=458.82a
    C35  (vdd\#4 3)  capacitor c=101.725a
    C56  (Y\#5 YN\#2313)  capacitor c=444.396a
    C67  (Y\#5 3)  capacitor c=227.6a
    C74  (YN\#2313 3)  capacitor c=1.28983e-15
    C1  (vdd\#4 vss)  capacitor c=16.6221a
    C11  (YN\#2313 vss)  capacitor c=5.6901e-18
    C20  (3 vss)  capacitor c=9.03131e-15
    C2  (A vss)  capacitor c=9.28312e-18
    C47  (3 A)  capacitor c=4.22697e-15
    C3  (A\#2 vss)  capacitor c=1.40653e-18
    C42  (Y\#5 A\#2)  capacitor c=3.94577e-18
    C48  (A\#2 3)  capacitor c=1.26397e-15
    C4  (vss\#3 A)  capacitor c=51.8544a
    C23  (vss\#3 3)  capacitor c=552.522a
    C5  (vss\#3 A\#4)  capacitor c=302.184a
    C49  (A\#4 3)  capacitor c=800.282a
    C6  (A\#3 vss\#3)  capacitor c=3.78432e-18
    C50  (A\#3 3)  capacitor c=224.19a
    C46  (A\#3 YN\#4)  capacitor c=16.3872a
    C16  (YN\#4 vss)  capacitor c=2.59084e-18
    C43  (YN\#4 A)  capacitor c=300.832a
    C24  (vdd\#3 A)  capacitor c=20.8062a
    C25  (vdd\#3 A\#2)  capacitor c=465.503a
    C32  (vdd\#3 YN\#4)  capacitor c=395.459a
    C36  (vdd\#3 3)  capacitor c=45.3471a
    C44  (YN\#4 A\#2)  capacitor c=473.469a
    C60  (YN\#4 Y\#5)  capacitor c=12.1626a
    C78  (YN\#4 3)  capacitor c=2.19804e-15
    C51  (A\#2 8)  capacitor c=531.582a
    C41  (vdd\#3 8)  capacitor c=803.227a
    C33  (3 vdd)  capacitor c=8.99848e-15
    C40  (8 vdd)  capacitor c=36.7943a
    C85  (YN\#4 8)  capacitor c=181.312a
    C7  (Y vss)  capacitor c=11.9486a
    C59  (YN\#4 Y)  capacitor c=12.6835a
    C64  (3 Y)  capacitor c=3.21879e-15
    C9  (YN\#5 vss)  capacitor c=8.1593e-19
    C72  (YN\#5 3)  capacitor c=1.21834e-15
    C10  (YN\#2311 vss)  capacitor c=7.16737e-18
    C55  (Y\#5 YN\#2311)  capacitor c=456.232a
    C73  (YN\#2311 3)  capacitor c=1.24282e-15
    C17  (vss\#3 YN\#3)  capacitor c=226.76a
    C45  (YN\#3 A\#4)  capacitor c=209.049a
    C79  (YN\#3 3)  capacitor c=226.641a
    C30  (vdd\#4 YN)  capacitor c=9.4262e-18
    C52  (YN Y)  capacitor c=637.311a
    C71  (3 YN)  capacitor c=4.52833e-15
    C61  (YN\#3 Y\#3)  capacitor c=3.0414e-18
    C68  (Y\#3 3)  capacitor c=315.719a
    C8  (Y\#3 vss\#1)  capacitor c=478.259a
    C21  (vss\#1 3)  capacitor c=5.72766e-15
    C14  (vss\#4 YN)  capacitor c=60.126a
    C22  (vss\#4 3)  capacitor c=186.57a
    C84  (YN\#2313 6)  capacitor c=522.726a
    C37  (6 vdd)  capacitor c=36.7943a
    C28  (vdd\#1 YN\#5)  capacitor c=430.104a
    C29  (vdd\#1 YN\#2311)  capacitor c=428.658a
    C34  (vdd\#1 3)  capacitor c=5.59392e-15
    C38  (vdd\#1 6)  capacitor c=154.573a
    C39  (vdd\#4 6)  capacitor c=149.256a
    C70  (Y\#5 6)  capacitor c=151.872a
    C82  (YN\#5 6)  capacitor c=481.565a
    C83  (YN\#2311 6)  capacitor c=511.031a
    C69  (Y\#1 6)  capacitor c=802.537a
    C19  (YN\#7 vss\#1)  capacitor c=24.5945a
    C26  (vdd\#1 Y\#1)  capacitor c=303.361a
    C53  (Y\#1 YN\#5)  capacitor c=468.463a
    C18  (YN\#6 vss\#1)  capacitor c=24.2067a
    C62  (YN\#6 Y)  capacitor c=767.135a
    C63  (YN\#7 Y)  capacitor c=1.0515e-15
    C65  (Y\#1 3)  capacitor c=279.493a
    C80  (YN\#6 3)  capacitor c=2.82269e-15
    C81  (YN\#7 3)  capacitor c=3.4762e-15
    C12  (vss\#1 YN\#9)  capacitor c=277.978a
    C75  (YN\#9 3)  capacitor c=717.713a
    C54  (Y\#4 YN\#9)  capacitor c=212.81a
    C66  (Y\#4 3)  capacitor c=1.00303e-15
    C13  (vss\#1 YN\#2310)  capacitor c=281.028a
    C15  (vss\#4 YN\#2312)  capacitor c=298.818a
    C57  (Y\#3 YN\#2310)  capacitor c=200.663a
    C58  (Y\#3 YN\#2312)  capacitor c=196.886a
    C76  (YN\#2310 3)  capacitor c=745.779a
    C77  (YN\#2312 3)  capacitor c=759.789a
    MX6_M0_unmatched  (Y\#5 YN\#2313 vdd\#4 vdd\#4)  pch w=1.2e-05 l=1e-06 \
        as=3.6e-11 ad=0 ps=3e-05 pd=0 sa=2e-06 sb=2e-06
    MM0  (YN\#4 A\#2 vdd\#3 vdd\#3)  pch w=1.2e-05 l=1e-06 as=0 ad=3e-11 \
        ps=0 pd=2.9e-05 sa=2e-06 sb=2e-06
    MM5  (Y\#5 YN\#2311 vdd\#1 vdd\#1)  pch w=1.2e-05 l=1e-06 as=0 \
        ad=3.6e-11 ps=0 pd=3e-05 sa=2e-06 sb=2e-06
    MM1  (Y\#1 YN\#5 vdd\#1 vdd\#1)  pch w=1.2e-05 l=1e-06 as=0 ad=3e-11 \
        ps=0 pd=2.9e-05 sa=2e-06 sb=2e-06
ends BUFX9
