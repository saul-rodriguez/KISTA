// DFFX1
simulator lang=spectre insensitive=yes
global vss vdd
subckt DFFX1 Q CK D QN
    C168  (vss\#9 Y2\#2311)  capacitor c=191.082a
    C51  (vdd\#1 D\#4)  capacitor c=183.136a
    C55  (vdd\#1 Y4\#9)  capacitor c=112.844a
    C92  (vss CK)  capacitor c=73.393a
    C110  (Y2\#9 CK)  capacitor c=1.30624e-18
    C112  (Y2\#2313 CK)  capacitor c=563.574a
    C114  (Y2\#2318 CK)  capacitor c=21.9745a
    C121  (9 CK)  capacitor c=14.6456f
    C141  (D\#4 vss)  capacitor c=4.90928e-18
    C156  (Y4\#9 vss)  capacitor c=4.35786e-18
    C173  (Y2\#2313 vss)  capacitor c=44.6487a
    C174  (Y2\#2318 vss)  capacitor c=5.39766e-19
    C193  (vss\#3 9)  capacitor c=65.4157f
    C208  (Y4\#9 D\#4)  capacitor c=771.126a
    C211  (D\#4 9)  capacitor c=1.81104e-15
    C307  (Y2\#9 9)  capacitor c=40.9597a
    C308  (Y2\#2313 9)  capacitor c=23.2188f
    C309  (Y2\#2318 9)  capacitor c=662.522a
    C5  (Q\#7 CK)  capacitor c=594.754a
    C33  (Q\#7 9)  capacitor c=3.46554e-15
    C6  (Q\#8 vss)  capacitor c=15.6511a
    C25  (Y2\#9 Q\#8)  capacitor c=1.26105e-18
    C27  (Y2\#2313 Q\#8)  capacitor c=544.078a
    C30  (Y2\#2318 Q\#8)  capacitor c=41.3263a
    C32  (Q\#8 9)  capacitor c=3.77983e-15
    C3  (vdd\#6 Q\#8)  capacitor c=467.788a
    C50  (vdd\#6 vss)  capacitor c=38.8954a
    C78  (vdd\#6 9)  capacitor c=64.726f
    C7  (Q\#1 vss)  capacitor c=9.62697e-18
    C35  (Q\#1 9)  capacitor c=4.50794e-15
    C4  (vdd\#8 Q\#1)  capacitor c=427.31a
    C8  (Q\#2 vss)  capacitor c=31.3269a
    C28  (Y2\#2313 Q\#2)  capacitor c=67.538a
    C36  (Q\#2 9)  capacitor c=811.341a
    C1  (Q\#2 vdd\#2319)  capacitor c=230.808a
    C9  (vss\#3 Q\#5)  capacitor c=178.583a
    C34  (Q\#5 9)  capacitor c=2.89073e-15
    C11  (Q\#8 QN)  capacitor c=844.687a
    C15  (Q\#2 QN)  capacitor c=256.994a
    C145  (QN vss)  capacitor c=25.9177a
    C218  (Y2\#9 QN)  capacitor c=7.1856e-19
    C220  (Y2\#2313 QN)  capacitor c=310.022a
    C222  (Y2\#2318 QN)  capacitor c=16.2282a
    C227  (9 QN)  capacitor c=6.44939e-15
    C12  (QN\#2310 Q\#1)  capacitor c=180.564a
    C24  (Y2\#9 Q)  capacitor c=7.15267e-19
    C26  (Y2\#2313 Q)  capacitor c=241.063a
    C29  (Y2\#2318 Q)  capacitor c=7.07813e-19
    C31  (9 Q)  capacitor c=1.88791e-15
    C148  (QN\#2310 vss)  capacitor c=7.48979e-18
    C231  (QN\#2310 9)  capacitor c=260.028a
    C38  (Q\#4 9)  capacitor c=282.311a
    C2  (vdd\#20 Q\#4)  capacitor c=130.415a
    C48  (vdd\#20 vss)  capacitor c=33.3334a
    C13  (QN\#7 Q\#7)  capacitor c=86.496a
    C14  (QN\#7 Q\#5)  capacitor c=105.993a
    C99  (QN\#7 CK)  capacitor c=200.507a
    C149  (QN\#7 vss)  capacitor c=1.4987e-18
    C232  (QN\#7 9)  capacitor c=705.553a
    C16  (Q\#2 QN\#5)  capacitor c=196.025a
    C54  (vdd\#2319 QN\#5)  capacitor c=235.812a
    C146  (QN\#5 vss)  capacitor c=3.9864e-18
    C228  (QN\#5 9)  capacitor c=597.868a
    C86  (vdd\#2319 X24_5)  capacitor c=169.229a
    C43  (Q\#2 X24_5)  capacitor c=436.112a
    C240  (QN\#5 X24_5)  capacitor c=513.467a
    C20  (QN\#2 Q\#2)  capacitor c=1.35919e-15
    C19  (QN\#2 Q\#8)  capacitor c=3.00538e-19
    C150  (QN\#2 vss)  capacitor c=1.70187e-18
    C219  (QN\#2 Y2\#9)  capacitor c=1.3711e-18
    C221  (Y2\#2313 QN\#2)  capacitor c=591.557a
    C223  (Y2\#2318 QN\#2)  capacitor c=1.36058e-18
    C233  (QN\#2 9)  capacitor c=4.49474e-15
    C18  (Q\#6 QN\#7)  capacitor c=87.5393a
    C37  (Q\#6 9)  capacitor c=665.791a
    C41  (net6\#2 Q\#5)  capacitor c=130.436a
    C40  (net6\#2 Q\#7)  capacitor c=110.892a
    C133  (net6\#2 CK)  capacitor c=70.5043a
    C200  (net6\#2 vss)  capacitor c=1.98222e-18
    C236  (QN\#7 net6\#2)  capacitor c=47.9632a
    C359  (net6\#2 9)  capacitor c=889.854a
    C22  (Y4\#7 Q\#7)  capacitor c=586.666a
    C103  (Y4\#7 CK)  capacitor c=1.51232e-15
    C201  (vss\#3 net6)  capacitor c=180.714a
    C242  (Y2\#9 Y4\#7)  capacitor c=4.46162e-18
    C244  (Y2\#2318 Y4\#7)  capacitor c=74.1721a
    C262  (Y4\#7 9)  capacitor c=28.5989f
    C358  (net6 9)  capacitor c=448.517a
    C10  (vss\#5 Q\#6)  capacitor c=114.174a
    C17  (Q\#6 QN\#4)  capacitor c=86.496a
    C152  (vss\#5 QN\#4)  capacitor c=217.739a
    C229  (QN\#4 9)  capacitor c=1.15999e-15
    C21  (QN\#3 Q\#6)  capacitor c=18.4731a
    C101  (QN\#3 CK)  capacitor c=595.333a
    C151  (QN\#3 vss)  capacitor c=4.46453e-18
    C234  (QN\#3 9)  capacitor c=4.49534e-15
    C216  (QN\#2 Y4)  capacitor c=293.75a
    C153  (Y4 vss)  capacitor c=28.9466a
    C217  (QN\#3 Y4)  capacitor c=293.961a
    C243  (Y2\#2313 Y4)  capacitor c=2.24244e-15
    C100  (CK\#2 QN\#7)  capacitor c=1.82522e-18
    C102  (QN\#3 CK\#2)  capacitor c=7.66249e-18
    C96  (CK\#2 vss)  capacitor c=6.48759e-18
    C104  (CK\#2 Y4)  capacitor c=615.539a
    C111  (Y2\#9 CK\#2)  capacitor c=8.43675e-21
    C113  (Y2\#2313 CK\#2)  capacitor c=504.294a
    C115  (Y2\#2318 CK\#2)  capacitor c=8.34883e-21
    C126  (CK\#2 9)  capacitor c=5.52407e-15
    C23  (Q\#4 Y2\#8)  capacitor c=258.467a
    C61  (vdd\#20 Y2\#8)  capacitor c=234.798a
    C164  (Y2\#8 vss)  capacitor c=14.1133a
    C300  (Y2\#8 9)  capacitor c=1.27273e-15
    C44  (Q\#4 X23_5)  capacitor c=188.398a
    C317  (Y2\#8 X23_5)  capacitor c=533.577a
    C87  (vdd\#20 X23_5)  capacitor c=162.469a
    C53  (QN\#2310 vdd\#2318)  capacitor c=206.238a
    C42  (Q\#8 X25_5)  capacitor c=512.454a
    C85  (vdd\#2318 X25_5)  capacitor c=169.229a
    C239  (QN\#2310 X25_5)  capacitor c=152.148a
    C238  (X25_5 QN)  capacitor c=9.91316e-18
    C39  (Q\#6 net4)  capacitor c=41.3514a
    C235  (QN\#4 net4)  capacitor c=83.616a
    C198  (vss\#5 net4)  capacitor c=73.2744a
    C356  (net4 9)  capacitor c=234.991a
    C130  (net4\#2 CK)  capacitor c=18.3381a
    C132  (CK\#2 net4\#2)  capacitor c=2.36029e-19
    C199  (vss\#5 net4\#2)  capacitor c=104.004a
    C357  (net4\#2 9)  capacitor c=235.227a
    C47  (vdd\#2317 vss)  capacitor c=29.2353a
    C49  (vdd\#21 vss)  capacitor c=31.0123a
    C46  (vdd\#21 CK\#4)  capacitor c=235.822a
    C94  (CK\#4 vss)  capacitor c=16.2759a
    C123  (CK\#4 9)  capacitor c=2.55947e-15
    C52  (vdd\#2317 QN\#8)  capacitor c=130.415a
    C147  (QN\#8 vss)  capacitor c=11.2116a
    C230  (QN\#8 9)  capacitor c=282.075a
    C59  (vdd\#2 Y4\#9)  capacitor c=15.2914a
    C79  (vdd\#1 X31_5)  capacitor c=175.347a
    C215  (D\#4 X31_5)  capacitor c=509.926a
    C275  (Y4\#9 X31_5)  capacitor c=448.721a
    C213  (D\#2 9)  capacitor c=4.29523e-15
    C62  (vdd\#21 Y2\#2314)  capacitor c=85.1701a
    C65  (vdd\#2310 Y2\#2314)  capacitor c=72.0822a
    C108  (Y2\#2314 CK\#4)  capacitor c=410.094a
    C169  (Y2\#2314 vss)  capacitor c=14.3906a
    C88  (vdd\#21 X22_5)  capacitor c=182.829a
    C140  (CK\#4 X22_5)  capacitor c=511.921a
    C318  (Y2\#2314 X22_5)  capacitor c=500.184a
    C63  (Y2\#2316 vdd\#22)  capacitor c=143.006a
    C66  (vdd\#22 Y1\#7)  capacitor c=235.79a
    C175  (Y1\#7 vss)  capacitor c=10.548a
    C279  (Y2\#2316 Y1\#7)  capacitor c=141.206a
    C322  (Y1\#7 9)  capacitor c=617.267a
    C89  (vdd\#22 X21_5)  capacitor c=182.829a
    C319  (Y2\#2316 X21_5)  capacitor c=318.488a
    C332  (Y1\#7 X21_5)  capacitor c=504.842a
    C178  (Y1\#8 vss)  capacitor c=9.26217e-19
    C248  (Y1\#8 Y4)  capacitor c=22.5824a
    C327  (Y1\#8 9)  capacitor c=435.479a
    C69  (Y1\#8 vdd\#23)  capacitor c=3.89199e-18
    C58  (vdd\#2312 Y4\#4)  capacitor c=239.793a
    C155  (Y4\#4 vss)  capacitor c=2.23261e-18
    C259  (Y4\#4 9)  capacitor c=2.0348e-15
    C64  (vdd\#23 Y2\#5)  capacitor c=235.625a
    C165  (Y2\#5 vss)  capacitor c=5.8558e-18
    C289  (Y1\#8 Y2\#5)  capacitor c=1.22492e-18
    C301  (Y2\#5 9)  capacitor c=1.21937e-15
    C67  (vdd\#23 Y1\#4)  capacitor c=226.4a
    C246  (Y1\#4 Y4)  capacitor c=288.196a
    C283  (Y1\#4 Y2\#5)  capacitor c=256.868a
    C324  (Y1\#4 9)  capacitor c=6.88362e-15
    C90  (vdd\#23 X20_5)  capacitor c=182.829a
    C320  (Y2\#5 X20_5)  capacitor c=496.099a
    C333  (Y1\#4 X20_5)  capacitor c=471.151a
    C171  (Y2\#2 vss)  capacitor c=2.02844e-18
    C241  (Y2\#2 Y4)  capacitor c=591.984a
    C286  (Y2\#2 Y1\#4)  capacitor c=504.281a
    C290  (Y1\#8 Y2\#2)  capacitor c=20.3537a
    C305  (Y2\#2 9)  capacitor c=4.91545e-15
    C68  (Y1\#6 vdd\#2312)  capacitor c=121.044a
    C247  (Y1\#6 Y4\#4)  capacitor c=162.408a
    C326  (Y1\#6 9)  capacitor c=211.195a
    C282  (Y1\#4 Y2)  capacitor c=686.86a
    C162  (Y2 vss)  capacitor c=5.04183e-18
    C288  (Y1\#8 Y2)  capacitor c=56.4699a
    C172  (Y2\#3 vss)  capacitor c=7.55211e-18
    C306  (Y2\#3 9)  capacitor c=4.05333e-15
    C176  (Y1\#9 vss)  capacitor c=5.58079e-18
    C245  (Y1\#9 Y4)  capacitor c=306.06a
    C323  (Y1\#9 9)  capacitor c=2.68393e-15
    C91  (vdd\#2312 X19_5)  capacitor c=608.62a
    C334  (Y1\#6 X19_5)  capacitor c=318.962a
    C278  (Y4\#4 X19_5)  capacitor c=504.33a
    C159  (Y4\#2 vss)  capacitor c=6.4659e-18
    C263  (Y4\#2 9)  capacitor c=5.89446e-15
    C74  (vdd\#2317 Y3)  capacitor c=19.7488a
    C180  (Y3 vss)  capacitor c=2.9973e-18
    C224  (Y3 QN)  capacitor c=51.8762a
    C226  (Y3\#2 QN)  capacitor c=152.093a
    C190  (Y3\#2 vss)  capacitor c=6.47527e-18
    C255  (Y3\#2 Y4\#7)  capacitor c=588.059a
    C292  (Y3\#2 Y2\#9)  capacitor c=1.28223e-18
    C293  (Y2\#2313 Y3)  capacitor c=101.723a
    C294  (Y2\#2313 Y3\#2)  capacitor c=553.217a
    C295  (Y2\#2318 Y3\#2)  capacitor c=42.0204a
    C341  (Y3\#2 9)  capacitor c=5.3415e-15
    C191  (Y3\#8 vss)  capacitor c=6.68224e-18
    C256  (Y3\#8 Y4\#7)  capacitor c=27.348a
    C296  (Y3\#8 Y2\#9)  capacitor c=1.71477e-18
    C297  (Y3\#8 Y2\#2313)  capacitor c=638.111a
    C117  (CK\#7 Y2\#2313)  capacitor c=7.27272e-19
    C97  (CK\#7 vss)  capacitor c=4.62752e-19
    C105  (CK\#7 Y4\#7)  capacitor c=42.52a
    C116  (CK\#7 Y2\#9)  capacitor c=1.68565e-21
    C107  (Y2\#2311 CK)  capacitor c=298.99a
    C109  (CK\#2 Y2\#2311)  capacitor c=3.84828e-18
    C118  (CK\#7 Y2\#2318)  capacitor c=5.5241e-20
    C127  (CK\#7 9)  capacitor c=369.981a
    C298  (Y3\#8 Y2\#2318)  capacitor c=56.1952a
    C303  (Y2\#2311 9)  capacitor c=2.76793e-15
    C314  (net4\#2 Y2\#2311)  capacitor c=83.616a
    C342  (Y3\#8 9)  capacitor c=6.4954e-15
    C75  (vdd\#2317 Y3\#4)  capacitor c=234.798a
    C182  (Y3\#4 vss)  capacitor c=12.3398a
    C225  (QN\#8 Y3\#4)  capacitor c=189.659a
    C336  (Y3\#4 9)  capacitor c=603.958a
    C119  (Y3\#3 CK)  capacitor c=585.494a
    C338  (Y3\#3 9)  capacitor c=3.1468e-15
    C343  (Y3\#3 net6)  capacitor c=96.5184a
    C189  (vss\#8 Y3\#3)  capacitor c=188.891a
    C84  (vdd\#2317 X26_5)  capacitor c=162.469a
    C237  (QN\#8 X26_5)  capacitor c=188.398a
    C351  (Y3\#4 X26_5)  capacitor c=510.168a
    C76  (vdd\#2 Y3\#5)  capacitor c=265.363a
    C184  (Y3\#5 vss)  capacitor c=5.14198e-18
    C339  (Y3\#5 9)  capacitor c=2.50294e-15
    C93  (CK\#6 vss)  capacitor c=14.7215a
    C120  (Y3\#8 CK\#6)  capacitor c=753.42a
    C122  (CK\#6 9)  capacitor c=2.49965e-15
    C45  (vdd\#2315 CK\#6)  capacitor c=235.657a
    C72  (vdd\#2315 Y3\#2311)  capacitor c=102.009a
    C187  (Y3\#2311 vss)  capacitor c=1.87456e-18
    C139  (CK\#6 X28_5)  capacitor c=504.842a
    C82  (vdd\#2315 X28_5)  capacitor c=182.829a
    C349  (Y3\#2311 X28_5)  capacitor c=314.368a
    C77  (vdd\#4 Y3\#2311)  capacitor c=68.6095a
    C188  (Y3\#9 vss)  capacitor c=6.27241e-18
    C73  (Y3\#9 vdd\#2316)  capacitor c=182.411a
    C71  (Y3\#6 vdd\#2314)  capacitor c=178.527a
    C186  (Y3\#6 vss)  capacitor c=15.8954a
    C56  (vdd\#2313 Y4\#2312)  capacitor c=112.853a
    C249  (Y4\#2312 Y3\#5)  capacitor c=56.1602a
    C70  (vdd\#2313 Y3\#2314)  capacitor c=162.869a
    C181  (Y3\#2314 vss)  capacitor c=8.59017e-18
    C253  (Y3\#6 Y4\#2312)  capacitor c=160.13a
    C335  (Y3\#2314 9)  capacitor c=2.35419e-15
    C80  (vdd\#2313 X30_5)  capacitor c=162.725a
    C276  (Y4\#2312 X30_5)  capacitor c=162.853a
    C347  (Y3\#2314 X30_5)  capacitor c=464.348a
    C160  (Y4\#2310 vss)  capacitor c=32.6403a
    C209  (Y4\#2310 D\#2)  capacitor c=8.29373e-18
    C257  (Y4\#2310 Y3\#2314)  capacitor c=852.845a
    C183  (Y3\#2315 vss)  capacitor c=8.01048e-18
    C337  (Y3\#2315 9)  capacitor c=3.05742e-15
    C207  (Y4\#9 D)  capacitor c=45.8825a
    C210  (9 D)  capacitor c=1.44894e-15
    C142  (vss\#1 D)  capacitor c=55.5743a
    C144  (D\#2 vss\#1)  capacitor c=14.997a
    C143  (vss\#1 D\#3)  capacitor c=131.959a
    C212  (D\#3 9)  capacitor c=822.513a
    C57  (vdd\#2314 Y4\#5)  capacitor c=235.657a
    C154  (Y4\#5 vss)  capacitor c=8.94266e-18
    C252  (Y3\#6 Y4\#5)  capacitor c=712.564a
    C258  (Y4\#5 9)  capacitor c=1.76792e-15
    C81  (vdd\#2314 X29_5)  capacitor c=162.849a
    C348  (Y3\#6 X29_5)  capacitor c=336.739a
    C277  (Y4\#5 X29_5)  capacitor c=519.508a
    C161  (vss\#3 Y4\#8)  capacitor c=65.151a
    C260  (Y4\#8 9)  capacitor c=2.11433e-15
    C60  (vdd\#2316 Y2\#2317)  capacitor c=235.657a
    C163  (Y2\#2317 vss)  capacitor c=9.55564e-18
    C291  (Y3\#9 Y2\#2317)  capacitor c=250.135a
    C299  (Y2\#2317 9)  capacitor c=1.24698e-15
    C106  (Y2\#2319 CK)  capacitor c=299.34a
    C302  (Y2\#2319 9)  capacitor c=2.62339e-15
    C83  (vdd\#2316 X27_5)  capacitor c=182.829a
    C316  (Y2\#2317 X27_5)  capacitor c=511.921a
    C350  (Y3\#9 X27_5)  capacitor c=498.124a
    C98  (vss\#3 CK\#8)  capacitor c=66.9436a
    C124  (CK\#8 9)  capacitor c=1.42798e-15
    C137  (CK\#7 net11)  capacitor c=6.92681e-19
    C134  (net11 CK)  capacitor c=10.9286a
    C136  (net11\#2 CK)  capacitor c=9.28575e-18
    C135  (CK\#8 net11)  capacitor c=83.616a
    C202  (vss\#3 net11)  capacitor c=73.7603a
    C203  (vss\#3 net11\#2)  capacitor c=105.129a
    C315  (net11\#2 Y2\#2319)  capacitor c=83.616a
    C360  (net11 9)  capacitor c=296.558a
    C361  (net11\#2 9)  capacitor c=235.172a
    C167  (vss\#7 Y2\#2319)  capacitor c=187.388a
    C125  (CK\#3 9)  capacitor c=1.35137e-15
    C131  (net4\#2 CK\#3)  capacitor c=1.12473e-18
    C311  (Y2\#2311 net9)  capacitor c=8.685e-19
    C128  (CK\#3 net9)  capacitor c=92.2495a
    C197  (vss\#5 net9)  capacitor c=179.845a
    C354  (net9 9)  capacitor c=451.872a
    C129  (CK\#2 net9\#2)  capacitor c=4.26612e-18
    C196  (net9\#2 vss)  capacitor c=1.78488e-18
    C268  (net9\#2 Y4)  capacitor c=13.1525a
    C313  (Y2\#3 net9\#2)  capacitor c=2.13244e-18
    C331  (net9\#2 Y1\#9)  capacitor c=110.831a
    C355  (net9\#2 9)  capacitor c=891.726a
    C95  (vss\#2310 CK\#3)  capacitor c=187.114a
    C179  (vss\#5 Y1)  capacitor c=134.823a
    C138  (net12\#2 CK\#8)  capacitor c=83.616a
    C366  (net12\#2 net11)  capacitor c=39.8112a
    C214  (D\#3 net1)  capacitor c=83.616a
    C267  (Y4\#2 net7\#2)  capacitor c=1.04099e-18
    C264  (net7 Y4)  capacitor c=3.42762e-18
    C265  (net7\#2 Y4)  capacitor c=2.47154e-18
    C274  (Y4\#2310 net1)  capacitor c=3.80737e-18
    C206  (vss\#1 net1)  capacitor c=72.8241a
    C185  (vss\#1 Y3\#2312)  capacitor c=133.001a
    C251  (Y4\#2313 Y3\#2312)  capacitor c=64.1783a
    C157  (Y4\#2313 vss)  capacitor c=7.05967e-18
    C166  (Y2\#4 vss)  capacitor c=65.9122a
    C170  (Y2\#7 vss)  capacitor c=10.4101a
    C177  (Y1\#2 vss)  capacitor c=90.2294a
    C284  (Y1\#2 Y2\#4)  capacitor c=80.8146a
    C285  (Y1\#2 Y2\#7)  capacitor c=51.7266a
    C194  (net7 vss)  capacitor c=72.6356a
    C310  (Y2\#4 net7)  capacitor c=83.616a
    C329  (Y1\#2 net7)  capacitor c=39.8112a
    C195  (net7\#2 vss)  capacitor c=104.004a
    C158  (vss\#6 Y4\#3)  capacitor c=190.717a
    C266  (net7\#2 Y4\#3)  capacitor c=83.616a
    C250  (Y4\#2313 Y3\#2315)  capacitor c=353.948a
    C261  (Y4\#3 9)  capacitor c=2.17871e-15
    C304  (Y2\#4 9)  capacitor c=813.887a
    C287  (Y2\#3 Y1\#2)  capacitor c=16.2336a
    C325  (Y1\#2 9)  capacitor c=221.343a
    C280  (Y2\#7 Y1)  capacitor c=70.5541a
    C321  (9 Y1)  capacitor c=2.52841e-15
    C328  (net7 Y1)  capacitor c=1.50952e-18
    C340  (Y3\#2312 9)  capacitor c=2.62186e-15
    C352  (net7 9)  capacitor c=237.088a
    C353  (net7\#2 9)  capacitor c=366.211a
    C364  (net1 9)  capacitor c=253.121a
    C192  (vss\#3 Y3\#2313)  capacitor c=77.1879a
    C344  (Y3\#2312 net12)  capacitor c=1.50952e-18
    C204  (vss\#3 net12)  capacitor c=72.6356a
    C205  (vss\#3 net12\#2)  capacitor c=73.7811a
    C345  (Y3\#2313 net12)  capacitor c=39.8112a
    C362  (net12 9)  capacitor c=365.974a
    C363  (net12\#2 9)  capacitor c=237.325a
    C365  (net1\#2 9)  capacitor c=253.375a
    C273  (Y4\#2313 net1\#2)  capacitor c=49.8475a
    C346  (net1\#2 Y3\#2315)  capacitor c=83.616a
    C272  (net1\#2 Y4\#8)  capacitor c=1.12473e-18
    C254  (Y3\#2313 Y4\#8)  capacitor c=80.8146a
    C269  (Y4\#8 net12)  capacitor c=83.616a
    C270  (Y4\#7 net12)  capacitor c=3.99902e-18
    C271  (net12\#2 Y4\#7)  capacitor c=3.42859e-18
    C281  (Y2\#7 Y1\#9)  capacitor c=80.8146a
    C330  (net9\#2 Y1)  capacitor c=142.353a
    C312  (Y2\#7 net9\#2)  capacitor c=46.0379a
    MX36_M0_unmatched  (net4\#2 Y2\#2311 vss\#9 vss\#9)  nch w=2e-06 \
        l=1e-06 as=0 ad=5e-12 ps=0 pd=9e-06 sa=2e-06 sb=2e-06
    MX38_M0_unmatched  (QN\#7 Q\#7 net6\#2 net6\#2)  nch w=2e-06 l=1e-06 \
        as=0 ad=5e-12 ps=0 pd=9e-06 sa=2e-06 sb=2e-06
    MX37_M0_unmatched  (Q\#6 QN\#4 net4 net4)  nch w=2e-06 l=1e-06 as=0 \
        ad=5e-12 ps=0 pd=9e-06 sa=2e-06 sb=2e-06
    MX39_M0_unmatched  (net6 Y3\#3 vss\#8 vss\#8)  nch w=2e-06 l=1e-06 \
        as=0 ad=5e-12 ps=0 pd=9e-06 sa=2e-06 sb=2e-06
    MX40_M0_unmatched  (net11\#2 Y2\#2319 vss\#7 vss\#7)  nch w=2e-06 \
        l=1e-06 as=0 ad=5e-12 ps=0 pd=9e-06 sa=2e-06 sb=2e-06
    MX35_M0_unmatched  (net9 CK\#3 vss\#2310 vss\#2310)  nch w=2e-06 \
        l=1e-06 as=0 ad=5e-12 ps=0 pd=9e-06 sa=2e-06 sb=2e-06
    MX41_M0_unmatched  (net12\#2 CK\#8 net11 net11)  nch w=2e-06 l=1e-06 \
        as=0 ad=5e-12 ps=0 pd=9e-06 sa=2e-06 sb=2e-06
    MX44_M0_unmatched  (net1 D\#3 vss\#1 vss\#1)  nch w=2e-06 l=1e-06 as=0 \
        ad=5e-12 ps=0 pd=9e-06 sa=2e-06 sb=2e-06
    MX33_M0_unmatched  (Y1\#2 Y2\#4 net7 net7)  nch w=2e-06 l=1e-06 as=0 \
        ad=5e-12 ps=0 pd=9e-06 sa=2e-06 sb=2e-06
    MX32_M0_unmatched  (net7\#2 Y4\#3 vss\#6 vss\#6)  nch w=2e-06 l=1e-06 \
        as=0 ad=5e-12 ps=0 pd=9e-06 sa=2e-06 sb=2e-06
    MX43_M0_unmatched  (Y4\#2313 Y3\#2315 net1\#2 net1\#2)  nch w=2e-06 \
        l=1e-06 as=0 ad=5e-12 ps=0 pd=9e-06 sa=2e-06 sb=2e-06
    MX42_M0_unmatched  (Y3\#2313 Y4\#8 net12 net12)  nch w=2e-06 l=1e-06 \
        as=0 ad=5e-12 ps=0 pd=9e-06 sa=2e-06 sb=2e-06
    MX34_M0_unmatched  (Y2\#7 Y1\#9 net9\#2 net9\#2)  nch w=2e-06 l=1e-06 \
        as=0 ad=5e-12 ps=0 pd=9e-06 sa=2e-06 sb=2e-06
    Rd13  (Y2\#9 Y2\#2313)  resistor r=85.8581
    Rc37  (Y2\#9 Y2\#2318)  resistor r=37433.4531
    Rc32  (Y2\#2318 Y2\#2313)  resistor r=86.7622
    Rs1  (9 vss)  resistor r=50
    Rd5  (Q\#7 Q\#8)  resistor r=3000
    Rd16  (Q\#8 Q\#1)  resistor r=1123.2664
    Rc65  (vdd\#6 vdd\#8)  resistor r=0.202
    Rd17  (Q\#1 Q\#2)  resistor r=23.1127
    Rc20  (vdd\#8 vdd\#2319)  resistor r=2.6224
    Rc69  (Q\#7 Q\#5)  resistor r=476.9571
    Rd18  (Q\#1 Q)  resistor r=3.2629
    Rc68  (QN QN\#2310)  resistor r=2.854
    Rc58  (Q Q\#2)  resistor r=3.199
    Rc70  (Q Q\#4)  resistor r=2.675
    Rd19  (vdd\#8 vdd\#20)  resistor r=7.9861
    Rd7  (QN\#2 QN\#5)  resistor r=736.0318
    Rd8  (QN\#2 QN\#2310)  resistor r=5555.1206
    Rc67  (QN\#2 QN)  resistor r=414.5314
    Rc57  (Q\#5 Q\#6)  resistor r=10.2
    Rc19  (net6 net6\#2)  resistor r=10.1779
    Rc14  (vss vss\#5)  resistor r=0.233
    Rc11  (vss\#3 vss\#5)  resistor r=300.4m
    Rd4  (QN\#3 QN\#4)  resistor r=436.0318
    Rc78  (QN\#2 QN\#3)  resistor r=2372.0635
    Rc56  (QN\#3 QN\#7)  resistor r=90.664
    Rc72  (CK\#2 CK)  resistor r=86.564
    Rc53  (Y4 Y4\#7)  resistor r=2
    Rc23  (Y2\#8 Y2\#9)  resistor r=1336.0317
    Rd21  (vdd\#20 vdd\#2310)  resistor r=3.9531
    Rc2  (vdd\#8 vdd\#2310)  resistor r=99.5m
    Rd22  (vdd\#2318 vdd\#8)  resistor r=8.0261
    Rd37  (vdd\#6 vdd\#2318)  resistor r=3.9931
    Rc8  (net4 net4\#2)  resistor r=10.1
    Rc77  (vdd\#6 vdd\#2317)  resistor r=2.6224
    Rd23  (vdd\#2310 vdd\#21)  resistor r=2.6224
    Rd30  (CK\#2 CK\#4)  resistor r=2536.0317
    Rd6  (QN\#8 QN)  resistor r=2.675
    Rd3  (vdd\#1 vdd\#2)  resistor r=2.7628
    Rc74  (D\#2 D\#4)  resistor r=1936.0317
    Rd33  (Y2\#2313 Y2\#2314)  resistor r=3.0041
    Rd35  (Y2\#2314 Y2\#2316)  resistor r=30.0947
    Rc31  (Y2\#2313 Y2\#2316)  resistor r=3.0642
    Rd20  (vdd\#2310 vdd\#22)  resistor r=10.6151
    Rc21  (vdd vdd\#2310)  resistor r=133.6m
    Rc22  (vdd vdd\#22)  resistor r=3.5266
    Rd39  (Y1\#7 Y1\#8)  resistor r=736.0318
    Rd27  (vdd vdd\#23)  resistor r=2.6083
    Rc75  (vdd vdd\#2312)  resistor r=2.7238
    Rd41  (Y1\#8 Y1\#4)  resistor r=172.4512
    Rc25  (Y2\#2 Y2\#5)  resistor r=1336.0317
    Rd29  (Y1\#4 Y1\#6)  resistor r=5.1243
    Rd25  (Y2\#2 Y2)  resistor r=85.464
    Rc35  (Y2 Y2\#2313)  resistor r=298.1m
    Rc24  (Y2\#2 Y2\#3)  resistor r=1772.0636
    Rc61  (Y1\#8 Y1\#6)  resistor r=175.9002
    Rc60  (Y1\#9 Y1\#8)  resistor r=2236.0317
    Rc44  (Y4\#2 Y4\#4)  resistor r=1936.0317
    Rc40  (Y4\#2 Y4)  resistor r=85.464
    Rd9  (Y3\#2 Y3)  resistor r=85.464
    Rc39  (Y3 Y3\#8)  resistor r=198.1m
    Rd26  (Y2\#9 Y2\#2311)  resistor r=2236.0317
    Rd31  (CK\#7 CK)  resistor r=85.564
    Rd11  (Y3\#2 Y3\#4)  resistor r=736.0318
    Rc33  (Y3\#2 Y3\#3)  resistor r=2836.0317
    Rc17  (vss\#3 vss\#8)  resistor r=5.0974
    Rc43  (Y3\#5 Y3\#8)  resistor r=6.7751
    Rd32  (CK\#6 CK\#7)  resistor r=2536.0317
    Rd44  (Y3\#8 Y3\#2311)  resistor r=2.8622
    Rc64  (vdd\#4 vdd\#2315)  resistor r=2.6224
    Rd43  (Y3\#2311 Y3\#9)  resistor r=46.3
    Rc76  (vdd\#2 vdd\#4)  resistor r=133.3m
    Rc66  (vdd\#4 vdd\#6)  resistor r=133.3m
    Rd38  (vdd\#2316 vdd\#6)  resistor r=3.5176
    Rd36  (vdd\#4 vdd\#2316)  resistor r=10.6948
    Rd1  (vdd\#2314 vdd\#4)  resistor r=3.5176
    Rd2  (vdd\#2 vdd\#2314)  resistor r=10.6948
    Rc63  (vdd\#2 vdd\#2313)  resistor r=2.7224
    Rc41  (Y3\#8 Y3\#9)  resistor r=2.8061
    Rd12  (Y3\#6 Y3\#8)  resistor r=3.3211
    Rd10  (Y3\#5 Y3\#6)  resistor r=30.7388
    Rd34  (Y3\#2314 Y3\#5)  resistor r=476.9571
    Rc48  (Y4\#2310 Y4\#2312)  resistor r=2.6731
    Rc34  (Y3\#2314 Y3\#2315)  resistor r=2400
    Rc47  (Y4\#7 Y4\#2310)  resistor r=0.279
    Rc54  (Y4\#2310 Y4\#9)  resistor r=2.9325
    Rc62  (D\#2 D)  resistor r=85.564
    Rd28  (D\#2 D\#3)  resistor r=436.0318
    Rc16  (vss\#1 vss\#3)  resistor r=5.5725
    Rc51  (Y4\#5 Y4\#6)  resistor r=1936.0317
    Rc52  (Y4\#6 Y4\#7)  resistor r=85.464
    Rc46  (Y4\#6 Y4\#8)  resistor r=1636.0317
    Rd15  (Y2\#2318 Y2\#2317)  resistor r=1336.0317
    Rc30  (Y2\#2318 Y2\#2319)  resistor r=2236.0317
    Rc59  (CK\#7 CK\#8)  resistor r=1036.0317
    Rc26  (net11 net11\#2)  resistor r=10.1
    Rc15  (vss\#1 vss\#7)  resistor r=869.3669
    Rc13  (vss\#7 vss\#3)  resistor r=5.1603
    Rc71  (CK\#2 CK\#3)  resistor r=1036.0317
    Rc7  (net9 net9\#2)  resistor r=10.1779
    Rc9  (vss\#5 vss\#2310)  resistor r=5.0974
    Rc10  (vss\#9 vss\#5)  resistor r=5.7562
    Rc18  (vss\#3 vss\#9)  resistor r=46.8634
    Rd42  (Y4\#2 Y4\#3)  resistor r=1636.0317
    Rc50  (Y4\#2310 Y4\#2313)  resistor r=8.0786
    Rc49  (vss vss\#6)  resistor r=5.0972
    Rc1  (net7 net7\#2)  resistor r=10.1
    Rc36  (Y3\#2315 Y3\#2312)  resistor r=476.9571
    Rd24  (Y2\#3 Y2\#4)  resistor r=436.0318
    Rd14  (Y2\#3 Y2\#7)  resistor r=90.564
    Rc73  (Y1 Y1\#2)  resistor r=10.1
    Rc42  (Y3\#2312 Y3\#2313)  resistor r=10.1
    Rc38  (net1 net1\#2)  resistor r=10.1
    Rc55  (Y4\#7 Y4\#2313)  resistor r=15.082
    Rc29  (net12 net12\#2)  resistor r=10.1
    Rd40  (Y1\#9 Y1)  resistor r=476.9571
    MX31_M0_unmatched  (Y4\#9 D\#4 vdd\#1 vdd\#1)  pch w=4e-06 l=1e-06 \
        as=0 ad=1e-11 ps=0 pd=1.3e-05 sa=2e-06 sb=2e-06
    MX24_M0_unmatched  (Q\#2 QN\#5 vdd\#2319 vdd\#2319)  pch w=4e-06 \
        l=1e-06 as=0 ad=1e-11 ps=0 pd=1.3e-05 sa=2e-06 sb=2e-06
    MX23_M0_unmatched  (Q\#4 Y2\#8 vdd\#20 vdd\#20)  pch w=4e-06 l=1e-06 \
        as=0 ad=1e-11 ps=0 pd=1.3e-05 sa=2e-06 sb=2e-06
    MX25_M0_unmatched  (QN\#2310 Q\#8 vdd\#2318 vdd\#2318)  pch w=4e-06 \
        l=1e-06 as=0 ad=1e-11 ps=0 pd=1.3e-05 sa=2e-06 sb=2e-06
    MX22_M0_unmatched  (Y2\#2314 CK\#4 vdd\#21 vdd\#21)  pch w=4e-06 \
        l=1e-06 as=0 ad=1e-11 ps=0 pd=1.3e-05 sa=2e-06 sb=2e-06
    MX21_M0_unmatched  (Y2\#2316 Y1\#7 vdd\#22 vdd\#22)  pch w=4e-06 \
        l=1e-06 as=0 ad=1e-11 ps=0 pd=1.3e-05 sa=2e-06 sb=2e-06
    MX20_M0_unmatched  (Y1\#4 Y2\#5 vdd\#23 vdd\#23)  pch w=4e-06 l=1e-06 \
        as=0 ad=1e-11 ps=0 pd=1.3e-05 sa=2e-06 sb=2e-06
    MX19_M0_unmatched  (Y1\#6 Y4\#4 vdd\#2312 vdd\#2312)  pch w=4e-06 \
        l=1e-06 as=0 ad=1e-11 ps=0 pd=1.3e-05 sa=2e-06 sb=2e-06
    MX26_M0_unmatched  (QN\#8 Y3\#4 vdd\#2317 vdd\#2317)  pch w=4e-06 \
        l=1e-06 as=0 ad=1e-11 ps=0 pd=1.3e-05 sa=2e-06 sb=2e-06
    MX28_M0_unmatched  (Y3\#2311 CK\#6 vdd\#2315 vdd\#2315)  pch w=4e-06 \
        l=1e-06 as=0 ad=1e-11 ps=0 pd=1.3e-05 sa=2e-06 sb=2e-06
    MX30_M0_unmatched  (Y4\#2312 Y3\#2314 vdd\#2313 vdd\#2313)  pch \
        w=4e-06 l=1e-06 as=0 ad=1e-11 ps=0 pd=1.3e-05 sa=2e-06 sb=2e-06
    MX29_M0_unmatched  (Y3\#6 Y4\#5 vdd\#2314 vdd\#2314)  pch w=4e-06 \
        l=1e-06 as=0 ad=1e-11 ps=0 pd=1.3e-05 sa=2e-06 sb=2e-06
    MX27_M0_unmatched  (Y3\#9 Y2\#2317 vdd\#2316 vdd\#2316)  pch w=4e-06 \
        l=1e-06 as=0 ad=1e-11 ps=0 pd=1.3e-05 sa=2e-06 sb=2e-06
ends DFFX1
