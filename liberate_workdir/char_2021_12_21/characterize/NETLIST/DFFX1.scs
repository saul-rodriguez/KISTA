// DFFX1
simulator lang=spectre insensitive=yes
global vss vdd
subckt DFFX1 Q D QN CK
    Rc49  (vss\#3 vss\#2312)  resistor r=5.1645
    Rc8  (D D\#1)  resistor r=5.0025
    Rc5  (n20\#2 n20\#5)  resistor r=2.72
    Rd17  (vss\#8 vss\#2317)  resistor r=5.1645
    Rc7  (n20\#2 n20\#3)  resistor r=5.1631
    Rd14  (CK\#3 CK)  resistor r=450.9377
    Rc58  (vss vss\#2310)  resistor r=5.1886
    Rc32  (n30\#2 n30\#4)  resistor r=5.1631
    Rc25  (mout\#3 mout\#8)  resistor r=2.7181
    Rc61  (vss\#6 vss\#2315)  resistor r=5.1645
    Rc20  (mout\#3 mout\#7)  resistor r=5.2631
    Rc50  (vss\#5 vss\#2314)  resistor r=5.1645
    Rc31  (n30\#8 n30)  resistor r=80.464
    Rd2  (n30 n30\#2)  resistor r=5.0795
    Rc33  (n30\#2 n30\#5)  resistor r=2.7181
    Rc47  (QN QN\#3)  resistor r=2.8181
    Rc46  (QN QN\#2)  resistor r=5.1631
    Rd8  (vdd\#1 vdd\#2)  resistor r=2.906
    Rd39  (net055\#5 net055\#6)  resistor r=1014.2584
    Rs1  (10 vss)  resistor r=50
    Rc83  (net055\#6 net055\#7)  resistor r=1434.2584
    Rd35  (net055\#6 net055)  resistor r=445.9252
    Rc41  (Q Q\#3)  resistor r=2.7206
    Rc40  (Q Q\#2)  resistor r=5.2606
    Rc68  (qbint\#7 qbint\#2311)  resistor r=999.0477
    Rd7  (vdd\#2 vdd\#2312)  resistor r=4.2474
    Rd9  (vdd\#2312 vdd\#4)  resistor r=8.5777
    Rc64  (vdd\#2 vdd\#4)  resistor r=0.621
    Rc53  (vdd\#2 vdd\#2311)  resistor r=2.7095
    Rd25  (qbint\#5 qbint\#6)  resistor r=1014.2584
    Rd24  (qbint\#6 qbint\#7)  resistor r=1117.6837
    Rc78  (qbint\#6 qbint\#9)  resistor r=1434.2584
    Rc73  (net055 net055\#4)  resistor r=10.3451
    Rd34  (net055 net055\#3)  resistor r=20.0314
    Rc57  (net055\#4 net055\#3)  resistor r=10.8255
    Rd13  (vss\#1 vss\#2311)  resistor r=151.663
    Rd15  (vss\#1 vss\#3)  resistor r=5.7608
    Rc59  (vss\#2311 vss\#3)  resistor r=5.5497
    Rd31  (qbint\#7 qbint\#2310)  resistor r=1419.0477
    Rc79  (qbint\#7 qbint\#8)  resistor r=2362.7004
    Rd4  (D\#2 D\#1)  resistor r=777.2892
    Rd5  (D\#1 D\#3)  resistor r=1347.2892
    Rd42  (vdd\#8 vdd\#2317)  resistor r=2.7345
    Rc9  (net14 net14\#2)  resistor r=5.1154
    Rc82  (CKbb\#8 CKbb\#2311)  resistor r=463.6361
    Rc10  (net13 net13\#2)  resistor r=10.1
    Rc51  (vss vss\#8)  resistor r=409.6m
    Rb1  (CKb\#8 CKb\#2313)  resistor r=538.6361
    Rd12  (CK\#2 CK\#3)  resistor r=864.2584
    Rc48  (CK\#3 CK\#4)  resistor r=1434.2584
    Rc63  (vdd vdd\#2310)  resistor r=2.7636
    Rc55  (vdd vdd\#8)  resistor r=408.5m
    Rc4  (vdd vdd\#2318)  resistor r=5.6939
    Rd1  (vdd\#8 vdd\#2318)  resistor r=5.6388
    Rb2  (CKb\#2310 CKb\#2314)  resistor r=864.2584
    Rc67  (CKb\#4 CKb\#3)  resistor r=10.7673
    Rd30  (CKb CKb\#3)  resistor r=20.1588
    Rc77  (CKb CKb\#4)  resistor r=10.3151
    Rd23  (CKb\#2310 CKb)  resistor r=370.9252
    Rc76  (CKb\#9 CKb\#2310)  resistor r=1434.2584
    Rd29  (CKb\#8 CKb\#9)  resistor r=2928.0679
    Rc66  (CKb\#7 CKb\#8)  resistor r=2988.5168
    Rd6  (vss\#8 vss\#2318)  resistor r=10.2888
    Rc52  (vss vss\#2318)  resistor r=10.7825
    Rc74  (CKbb\#2 CKbb\#4)  resistor r=10.6105
    Rd40  (CKbb CKbb\#4)  resistor r=21.8576
    Rc72  (CKbb CKbb\#2)  resistor r=10.0081
    Rd33  (CKbb\#8 CKbb)  resistor r=2001.5475
    Rd37  (CKbb\#7 CKbb\#8)  resistor r=4188.5166
    Rc54  (vdd\#4 vdd\#2313)  resistor r=2.7095
    Rc34  (net029 net029\#2)  resistor r=5.075
    Rd26  (qbint\#8 qbint\#2313)  resistor r=997.5659
    Rd36  (CKbb\#5 CKbb\#6)  resistor r=3453.0679
    Rd38  (CKbb\#6 CKbb\#7)  resistor r=1188.5167
    Rc81  (CKbb\#6 CKbb\#9)  resistor r=3858.8735
    Rc71  (CKbb\#7 CKbb\#2310)  resistor r=3991.2551
    Rc26  (n30\#2 n30\#2310)  resistor r=3.9915
    Rc29  (n30\#2310 n30\#2313)  resistor r=27.1489
    Rc30  (n30\#2 n30\#2313)  resistor r=7.3129
    Rc35  (net028 net028\#2)  resistor r=10.1
    Rc75  (CKb\#6 CKb\#5)  resistor r=4728.0679
    Rb3  (CKb\#6 CKb\#7)  resistor r=1188.5167
    Rd28  (CKb\#6 CKb\#2311)  resistor r=3633.8735
    Rd22  (CKb\#7 CKb\#2312)  resistor r=3766.2549
    Rc15  (net018 net018\#2)  resistor r=5.075
    Rc65  (vdd\#6 vdd\#2315)  resistor r=2.7095
    Rc12  (mout mout\#2)  resistor r=1006.0318
    Rd43  (vdd\#6 vdd\#8)  resistor r=0.621
    Rc2  (vdd\#2316 vdd\#8)  resistor r=8.5777
    Rd41  (vdd\#6 vdd\#2316)  resistor r=4.2474
    Rc56  (vdd\#4 vdd\#6)  resistor r=835.5m
    Rd11  (vdd\#4 vdd\#2314)  resistor r=3.7973
    Rd10  (vdd\#2314 vdd\#6)  resistor r=11.5401
    Rc3  (n30\#7 n30\#8)  resistor r=1006.0318
    Rc28  (n20\#6 n20\#7)  resistor r=1014.2584
    Rc36  (n20\#7 n20\#2)  resistor r=750.9252
    Rc37  (n20\#7 n20\#8)  resistor r=1434.2584
    Rc38  (n20\#2 n20)  resistor r=174.5m
    Rc6  (n20 n20\#2310)  resistor r=3.7217
    Rc11  (n20 n20\#2312)  resistor r=6.8186
    Rc14  (n20\#2310 n20\#2312)  resistor r=32.8723
    Rc16  (net017 net017\#2)  resistor r=10.1
    Rc21  (mout\#2 mout\#3)  resistor r=47.964
    Rc22  (mout\#2 mout\#4)  resistor r=1426.0319
    Rd18  (vss\#6 vss\#8)  resistor r=607.4m
    Rc62  (vss\#2316 vss\#8)  resistor r=15.9906
    Rd21  (vss\#6 vss\#2316)  resistor r=7.918
    Rd16  (vss\#5 vss\#6)  resistor r=596.2m
    Rc60  (vss\#3 vss\#5)  resistor r=607.4m
    Rd19  (vss\#3 vss\#2313)  resistor r=15.9906
    Rd20  (vss\#2313 vss\#5)  resistor r=7.918
    Rd3  (n30\#8 n30\#9)  resistor r=1426.0319
    Rc69  (qbint\#8 qbint\#2312)  resistor r=1417.5659
    Rd27  (qbint\#8 qbint)  resistor r=82.8419
    Rd32  (qbint qbint\#3)  resistor r=20.215
    Rc80  (qbint qbint\#4)  resistor r=10.4399
    Rc70  (qbint\#4 qbint\#3)  resistor r=10.7906
    Rc23  (mout\#3 mout\#9)  resistor r=3.611
    Rc17  (mout\#3 mout\#2311)  resistor r=6.9897
    Rc24  (mout\#9 mout\#2311)  resistor r=32.3608
    C4  (vss D)  capacitor c=347.57a
    C11  (vss CK)  capacitor c=1.94469e-15
    C9  (QN\#3 vss)  capacitor c=1.77117e-15
    C8  (vss QN)  capacitor c=2.99091e-15
    C10  (QN\#2 vss)  capacitor c=880.953a
    C16  (vdd\#1 vss)  capacitor c=506.526a
    C65  (net055\#5 vss)  capacitor c=921.882a
    C69  (10 vss)  capacitor c=64.0779f
    C82  (21 vss)  capacitor c=1.94456e-15
    C83  (X41_5 vss)  capacitor c=1.14629e-15
    C84  (X40_5 vss)  capacitor c=879.514a
    C85  (X39_5 vss)  capacitor c=842.637a
    C86  (X38_5 vss)  capacitor c=895.192a
    C87  (X37_5 vss)  capacitor c=944.088a
    C88  (X36_5 vss)  capacitor c=1.49854e-15
    C89  (X35_5 vss)  capacitor c=1.38207e-15
    C90  (X34_5 vss)  capacitor c=957.737a
    C91  (X33_5 vss)  capacitor c=954.539a
    C92  (X32_5 vss)  capacitor c=873.236a
    C93  (X31_5 vss)  capacitor c=935.113a
    C94  (X30_5 vss)  capacitor c=1.07878e-15
    C95  (X29_5 vss)  capacitor c=1.23814e-15
    C96  (vdd\#2 10)  capacitor c=40.8588f
    C142  (net055\#5 10)  capacitor c=978.96a
    C68  (net055\#6 vss)  capacitor c=282.077a
    C146  (net055\#6 10)  capacitor c=3.10866e-15
    C66  (net055\#7 vss)  capacitor c=357.581a
    C143  (net055\#7 10)  capacitor c=1.97197e-15
    C141  (10 net055)  capacitor c=1.63853e-15
    C1  (vss Q)  capacitor c=2.98659e-15
    C2  (Q\#3 vss)  capacitor c=951.892a
    C3  (Q\#2 vss)  capacitor c=1.14529e-15
    C18  (vdd\#2312 vss)  capacitor c=495.603a
    C57  (qbint\#2311 vss)  capacitor c=962.419a
    C132  (qbint\#2311 10)  capacitor c=991.562a
    C64  (qbint\#7 vss)  capacitor c=1.64582e-15
    C140  (qbint\#7 10)  capacitor c=6.03761e-15
    C17  (vdd\#2311 vss)  capacitor c=476.565a
    C56  (qbint\#5 vss)  capacitor c=962.56a
    C67  (net055\#4 vss)  capacitor c=1.27654e-15
    C131  (qbint\#5 10)  capacitor c=991.231a
    C63  (qbint\#6 vss)  capacitor c=609.929a
    C139  (qbint\#6 10)  capacitor c=3.80757e-15
    C144  (net055\#4 10)  capacitor c=2.15147e-15
    C59  (qbint\#9 vss)  capacitor c=376.151a
    C134  (qbint\#9 10)  capacitor c=2.01378e-15
    C145  (net055\#3 10)  capacitor c=800.821a
    C60  (qbint\#2310 vss)  capacitor c=376.011a
    C135  (qbint\#2310 10)  capacitor c=2.01378e-15
    C7  (D\#1 vss)  capacitor c=3.55126e-15
    C5  (D\#2 vss)  capacitor c=1.63917e-15
    C6  (D\#3 vss)  capacitor c=2.17038e-15
    C23  (vdd\#2317 vss)  capacitor c=568.817a
    C77  (net14\#2 vss)  capacitor c=8.26e-16
    C76  (net14 vss)  capacitor c=475.361a
    C39  (CKbb\#2311 vss)  capacitor c=863.708a
    C112  (CKbb\#2311 10)  capacitor c=773.645a
    C45  (CKbb\#8 vss)  capacitor c=1.18828e-15
    C119  (CKbb\#8 10)  capacitor c=6.87641e-15
    C122  (n20\#2 10)  capacitor c=10.4793f
    C71  (net13\#2 vss)  capacitor c=420.625a
    C70  (net13 vss)  capacitor c=384.04a
    C31  (CKb\#2313 vss)  capacitor c=248.461a
    C102  (CKb\#2313 10)  capacitor c=1.42424e-15
    C36  (CKb\#8 vss)  capacitor c=1.28355e-15
    C108  (CKb\#8 10)  capacitor c=6.34425e-15
    C14  (CK\#3 vss)  capacitor c=3.32019e-15
    C12  (CK\#2 vss)  capacitor c=1.76017e-15
    C13  (CK\#4 vss)  capacitor c=2.37844e-15
    C25  (vdd\#2310 vss)  capacitor c=727.308a
    C15  (vdd vss)  capacitor c=66.8392a
    C33  (CKb\#4 vss)  capacitor c=1.6233e-15
    C104  (CKb\#4 10)  capacitor c=1.839e-15
    C24  (vdd\#2318 vss)  capacitor c=585.67a
    C29  (CKb\#2314 vss)  capacitor c=945.241a
    C42  (CKbb\#2 vss)  capacitor c=2.38904e-15
    C100  (CKb\#2314 10)  capacitor c=812.722a
    C37  (CKb\#2310 vss)  capacitor c=263.047a
    C109  (CKb\#2310 10)  capacitor c=2.85121e-15
    C115  (CKbb\#2 10)  capacitor c=1.47464e-15
    C105  (CKb\#3 10)  capacitor c=976.506a
    C97  (10 CKb)  capacitor c=1.70562e-15
    C32  (CKb\#9 vss)  capacitor c=1.05787e-15
    C103  (CKb\#9 10)  capacitor c=4.67034e-15
    C35  (CKb\#7 vss)  capacitor c=2.06769e-15
    C107  (CKb\#7 10)  capacitor c=7.9493e-15
    C116  (CKbb\#4 10)  capacitor c=1.55741e-15
    C110  (10 CKbb)  capacitor c=3.6996e-15
    C44  (CKbb\#7 vss)  capacitor c=2.22744e-15
    C118  (CKbb\#7 10)  capacitor c=8.21978e-15
    C19  (vdd\#2313 vss)  capacitor c=1.11588e-15
    C58  (qbint\#2313 vss)  capacitor c=840.916a
    C81  (net029\#2 vss)  capacitor c=560.569a
    C80  (net029 vss)  capacitor c=545.499a
    C133  (qbint\#2313 10)  capacitor c=930.249a
    C38  (CKbb\#5 vss)  capacitor c=1.08842e-15
    C111  (CKbb\#5 10)  capacitor c=4.20519e-15
    C43  (CKbb\#6 vss)  capacitor c=3.4661e-15
    C117  (CKbb\#6 10)  capacitor c=7.68438e-15
    C40  (CKbb\#9 vss)  capacitor c=2.51293e-15
    C41  (CKbb\#2310 vss)  capacitor c=1.70374e-15
    C113  (CKbb\#9 10)  capacitor c=4.58869e-15
    C114  (CKbb\#2310 10)  capacitor c=4.96923e-15
    C55  (n30\#2 vss)  capacitor c=7.81656e-15
    C129  (n30\#2 10)  capacitor c=12.8619f
    C30  (CKb\#5 vss)  capacitor c=1.18287e-15
    C74  (net028 vss)  capacitor c=402.281a
    C75  (net028\#2 vss)  capacitor c=415.914a
    C101  (CKb\#5 10)  capacitor c=5.88243e-15
    C34  (CKb\#6 vss)  capacitor c=1.50615e-15
    C106  (CKb\#6 10)  capacitor c=9.21044e-15
    C27  (CKb\#2311 vss)  capacitor c=3.00704e-15
    C28  (CKb\#2312 vss)  capacitor c=1.81357e-15
    C98  (CKb\#2311 10)  capacitor c=4.41876e-15
    C99  (CKb\#2312 10)  capacitor c=4.52289e-15
    C78  (net018 vss)  capacitor c=463.421a
    C79  (net018\#2 vss)  capacitor c=456.596a
    C21  (vdd\#2315 vss)  capacitor c=725.755a
    C26  (vdd\#6 vss)  capacitor c=3.88751e-15
    C50  (mout vss)  capacitor c=851.417a
    C124  (10 mout)  capacitor c=919.597a
    C22  (vdd\#2316 vss)  capacitor c=638.419a
    C20  (vdd\#2314 vss)  capacitor c=936.943a
    C53  (n30\#7 vss)  capacitor c=958.937a
    C62  (qbint\#4 vss)  capacitor c=2.92544e-15
    C127  (n30\#7 10)  capacitor c=893.338a
    C137  (qbint\#4 10)  capacitor c=2.38132e-15
    C47  (n20\#6 vss)  capacitor c=952.957a
    C52  (mout\#3 vss)  capacitor c=8.12815e-15
    C120  (n20\#6 10)  capacitor c=1.00511e-15
    C49  (n20\#7 vss)  capacitor c=241.586a
    C123  (n20\#7 10)  capacitor c=3.44683e-15
    C126  (mout\#3 10)  capacitor c=10.8875f
    C46  (n20 vss)  capacitor c=7.13546e-15
    C48  (n20\#8 vss)  capacitor c=352.428a
    C121  (n20\#8 10)  capacitor c=1.98471e-15
    C72  (net017 vss)  capacitor c=588.67a
    C73  (net017\#2 vss)  capacitor c=575.009a
    C51  (mout\#4 vss)  capacitor c=232.808a
    C125  (mout\#4 10)  capacitor c=1.93316e-15
    C61  (qbint\#2312 vss)  capacitor c=233.255a
    C54  (n30\#9 vss)  capacitor c=351.983a
    C128  (n30\#9 10)  capacitor c=1.86673e-15
    C136  (qbint\#2312 10)  capacitor c=1.92327e-15
    C130  (10 qbint)  capacitor c=6.82658e-15
    C138  (qbint\#3 10)  capacitor c=870.725a
    MX26_M0_unmatched  (Q\#2 qbint\#2310 vss\#2312 vss\#2312)  nch w=2e-06 \
        l=1e-06 as=0 ad=5e-12 ps=0 pd=9e-06 sa=2e-06 sb=2e-06
    MX17_M0_unmatched  (net13\#2 D\#3 vss\#2317 vss\#2317)  nch w=2e-06 \
        l=1e-06 as=0 ad=5e-12 ps=0 pd=9e-06 sa=2e-06 sb=2e-06
    MX18_M0_unmatched  (n20\#3 CKb\#2313 net13 net13)  nch w=2e-06 l=1e-06 \
        as=0 ad=5e-12 ps=0 pd=9e-06 sa=2e-06 sb=2e-06
    MX15_M0_unmatched  (CKb\#3 CK\#4 vss\#2310 vss\#2310)  nch w=2e-06 \
        l=1e-06 as=0 ad=5e-12 ps=0 pd=9e-06 sa=2e-06 sb=2e-06
    MX22_M0_unmatched  (n30\#4 CKbb\#9 mout\#2311 mout\#2311)  nch w=2e-06 \
        l=1e-06 as=0 ad=5e-12 ps=0 pd=9e-06 sa=2e-06 sb=2e-06
    MX20_M0_unmatched  (net017\#2 mout\#4 vss\#2315 vss\#2315)  nch \
        w=2e-06 l=1e-06 as=0 ad=5e-12 ps=0 pd=9e-06 sa=2e-06 sb=2e-06
    MX19_M0_unmatched  (mout\#7 n20\#8 vss\#2316 vss\#2316)  nch w=2e-06 \
        l=1e-06 as=0 ad=5e-12 ps=0 pd=9e-06 sa=2e-06 sb=2e-06
    MX23_M0_unmatched  (qbint\#3 n30\#9 vss\#2314 vss\#2314)  nch w=2e-06 \
        l=1e-06 as=0 ad=5e-12 ps=0 pd=9e-06 sa=2e-06 sb=2e-06
    MX28_M0_unmatched  (QN\#2 net055\#7 vss\#1 vss\#1)  nch w=2e-06 \
        l=1e-06 as=0 ad=5e-12 ps=0 pd=9e-06 sa=2e-06 sb=2e-06
    MX27_M0_unmatched  (net055\#3 qbint\#9 vss\#2311 vss\#2311)  nch \
        w=2e-06 l=1e-06 as=0 ad=5e-12 ps=0 pd=9e-06 sa=2e-06 sb=2e-06
    MX16_M0_unmatched  (CKbb\#4 CKb\#9 vss\#2318 vss\#2318)  nch w=2e-06 \
        l=1e-06 as=0 ad=5e-12 ps=0 pd=9e-06 sa=2e-06 sb=2e-06
    MX25_M0_unmatched  (n30\#2313 CKb\#5 net028 net028)  nch w=2e-06 l=1e-06 \
        as=0 ad=5e-12 ps=0 pd=9e-06 sa=2e-06 sb=2e-06
    MX21_M0_unmatched  (n20\#2312 CKbb\#2310 net017 net017)  nch w=2e-06 \
        l=1e-06 as=0 ad=5e-12 ps=0 pd=9e-06 sa=2e-06 sb=2e-06
    MX24_M0_unmatched  (net028\#2 qbint\#2312 vss\#2313 vss\#2313)  nch \
        w=2e-06 l=1e-06 as=0 ad=5e-12 ps=0 pd=9e-06 sa=2e-06 sb=2e-06
    MX32_M0_unmatched  (n20\#5 CKbb\#2311 net14 net14)  pch w=4e-06 l=1e-06 \
        as=0 ad=1e-11 ps=0 pd=1.3e-05 sa=2e-06 sb=2e-06
    MX33_M0_unmatched  (mout\#8 n20\#6 vdd\#2316 vdd\#2316)  pch w=4e-06 \
        l=1e-06 as=0 ad=1e-11 ps=0 pd=1.3e-05 sa=2e-06 sb=2e-06
    MM14  (n30\#5 CKb\#2311 mout\#9 mout\#9)  pch w=4e-06 l=1e-06 as=0 \
        ad=1e-11 ps=0 pd=1.3e-05 sa=2e-06 sb=2e-06
    MX41_M0_unmatched  (QN\#3 net055\#5 vdd\#1 vdd\#1)  pch w=4e-06 \
        l=1e-06 as=0 ad=1e-11 ps=0 pd=1.3e-05 sa=2e-06 sb=2e-06
    MX39_M0_unmatched  (Q\#3 qbint\#2311 vdd\#2312 vdd\#2312)  pch w=4e-06 \
        l=1e-06 as=0 ad=1e-11 ps=0 pd=1.3e-05 sa=2e-06 sb=2e-06
    MX40_M0_unmatched  (net055\#4 qbint\#5 vdd\#2311 vdd\#2311)  pch \
        w=4e-06 l=1e-06 as=0 ad=1e-11 ps=0 pd=1.3e-05 sa=2e-06 sb=2e-06
    MX31_M0_unmatched  (net14\#2 D\#2 vdd\#2317 vdd\#2317)  pch w=4e-06 \
        l=1e-06 as=0 ad=1e-11 ps=0 pd=1.3e-05 sa=2e-06 sb=2e-06
    MX29_M0_unmatched  (CKb\#4 CK\#2 vdd\#2310 vdd\#2310)  pch w=4e-06 \
        l=1e-06 as=0 ad=1e-11 ps=0 pd=1.3e-05 sa=2e-06 sb=2e-06
    MX30_M0_unmatched  (CKbb\#2 CKb\#2314 vdd\#2318 vdd\#2318)  pch \
        w=4e-06 l=1e-06 as=0 ad=1e-11 ps=0 pd=1.3e-05 sa=2e-06 sb=2e-06
    MX37_M0_unmatched  (net029\#2 qbint\#2313 vdd\#2313 vdd\#2313)  pch \
        w=4e-06 l=1e-06 as=0 ad=1e-11 ps=0 pd=1.3e-05 sa=2e-06 sb=2e-06
    MX38_M0_unmatched  (n30\#2310 CKbb\#5 net029 net029)  pch w=4e-06 \
        l=1e-06 as=0 ad=1e-11 ps=0 pd=1.3e-05 sa=2e-06 sb=2e-06
    MX35_M0_unmatched  (n20\#2310 CKb\#2312 net018 net018)  pch w=4e-06 \
        l=1e-06 as=0 ad=1e-11 ps=0 pd=1.3e-05 sa=2e-06 sb=2e-06
    MX34_M0_unmatched  (net018\#2 mout vdd\#2315 vdd\#2315)  pch w=4e-06 \
        l=1e-06 as=0 ad=1e-11 ps=0 pd=1.3e-05 sa=2e-06 sb=2e-06
    MX36_M0_unmatched  (qbint\#4 n30\#7 vdd\#2314 vdd\#2314)  pch w=4e-06 \
        l=1e-06 as=0 ad=1e-11 ps=0 pd=1.3e-05 sa=2e-06 sb=2e-06
ends DFFX1
